| u58a.ibs * IBIS 4.0 Model
| 1Gb DDR-2 SDRAM - Die Revision "G"
| This Model is valid for Commercial Temperature Range 0C<=Ta< 85C
| Valid for DDR2-400/533/667/800 operation
| Models *_533 are applicable for speed grade 400/533 Mbps
| Models *_800 are applicable for speed grade 667/800 Mbps
|  Part Number   VDD/VDDQ   Architecture   Package
| MT47H256M4HQ   1.8V/1.8V   256Meg x 4   60-Ball FBGA
| MT47H256M4HQ_CLP  1.8V/1.8V   256Meg x 4   Common Landing Pattern
| MT47H128M8HQ   1.8V/1.8V   128Meg x 8   60-Ball FBGA
| MT47H128M8HQ_CLP  1.8V/1.8V   128Meg x 8   Common Landing Pattern
| MT47H64M16HR   1.8V/1.8V   64Meg x 16   84-Ball FBGA
| MT47H64M16HR_CLP  1.8V/1.8V   64Meg x 16   Common Landing Pattern
| MT47H256M4U58A   1.8V/1.8V   256Meg x 4   Bare Die
| MT47H128M8U58A   1.8V/1.8V   128Meg x 8   Bare Die
| MT47H64M16U58A   1.8V/1.8V   64Meg x 16   Bare Die
[IBIS Ver]   3.2
[File name]   MT47H_1GB_DDR2.ibs
[Date]   12/18/2009
[File Rev]   2.2
[Source]   From silicon level SPICE model at Micron Technology, Inc.
   For support e-mail modelsupport@micron.com
[Notes]   Revision History:
   Rev 1.0: 11/02/2007
   - Pre silicon model
   Rev 2.0: 04/02/2008
   - Model matched to latest silicon measurements
   - Updated all models
   - Updated c_comp for all models
   - File includes models for Packaged and Bare Die components
   - File includes modesl for all speed grades 400/533,667/800,1067
   Rev 2.1: 05/13/2008
   - Updated DQ models with corrected driver characteristics and ccomp
   - Updated HALF & FULL drive model characteristics based on new trim codes
   Rev 2.2: 12/18/2009
   - Updated HALF & FULL drive model characteristics based on new trim codes.
   - Deleted the 1067 models. Die Revision "G" does not support this speed grade.
   - Model data extracted from HSPICE model revision 2.3
   - There will be some WARNINGs regarding non-monotonic data for ODT submodels.
   - Slow corner V-t curves in the following DQ* models
   are shifted relative to strong and typical corner V-t curve
   to contain all 3 corners within appropriate V-t window
   Models   Slow   V-t duration
   DQ_FULL_533   -310ps   1.875ns
   DQ_HALF_533   -310ps   1.875ns
   DQ_FULL_800   -530ps   1.250ns
   DQ_HALF_800   -530ps   1.490ns
|IQ SUMMARY Overall Quality of component and models Level 2b
|See Micron IBIS Model Quality Report for full IQ SUMMARY
[Disclaimer]  This software code and all associated documentation, comments
              or other information (collectively "Software") is provided
              "AS IS" without warranty of any kind. MICRON TECHNOLOGY, INC.
              ("MTI") EXPRESSLY DISCLAIMS ALL WARRANTIES EXPRESS OR IMPLIED,
              INCLUDING BUT NOT LIMITED TO, NONINFRINGEMENT OF THIRD PARTY
              RIGHTS, AND ANY IMPLIED WARRANTIES OF MERCHANTABILITY OR
              FITNESS FOR ANY PARTICULAR PURPOSE. MTI DOES NOT WARRANT THAT
              THE SOFTWARE WILL MEET YOUR REQUIREMENTS, OR THAT THE
              OPERATION OF THE SOFTWARE WILL BE UNINTERRUPTED OR ERROR-FREE.
              FURTHERMORE, MTI DOES NOT MAKE ANY REPRESENTATIONS REGARDING
              THE USE OR THE RESULTS OF THE USE OF THE SOFTWARE IN TERMS OF
              ITS CORRECTNESS, ACCURACY, RELIABILITY, OR OTHERWISE. THE
              ENTIRE RISK ARISING OUT OF USE OR PERFORMANCE OF THE SOFTWARE
              REMAINS WITH YOU. IN NO EVENT SHALL MTI, ITS AFFILIATED
              COMPANIES OR THEIR SUPPLIERS BE LIABLE FOR ANY DIRECT,
              INDIRECT, CONSEQUENTIAL, INCIDENTAL, OR SPECIAL DAMAGES
              (INCLUDING, WITHOUT LIMITATION, DAMAGES FOR LOSS OF PROFITS,
              BUSINESS INTERRUPTION, OR LOSS OF INFORMATION) ARISING OUT OF
              YOUR USE OF OR INABILITY TO USE THE SOFTWARE, EVEN IF MTI HAS
              BEEN ADVISED OF THE POSSIBILITY OF SUCH DAMAGES. Because some
              jurisdictions prohibit the exclusion or limitation of
              liability for consequential or incidental damages, the above
              limitation may not apply to you.
[Copyright]   Copyright 2007 Micron Technology, Inc. All rights reserved.
|   COMPONENT: MT47H256M4HQ (60-Ball FBGA, x4, 8mm X 11.5mm)
[Component]   MT47H256M4HQ
[Package Model] U58A_8x10_x8
[Manufacturer]  Micron Technology,Inc.
[Package]
|   typ   min   max
R_pkg   178.43m   123.00m   295.00m
L_pkg   1.88nH   1.29nH   2.88nH
C_pkg   0.31pF   0.20pF   0.54pF
[Pin]   signal_name model_name   R_pin   L_pin   C_pin
A1   VDD   POWER
A2   NC   NF_INPUT   203.00m   2.29nH   0.38pF
A3   VSS   GND
A7   VSSQ   GND
A8   NU_DQS#   DQS#   213.00m   2.17nH   0.39pF
A9   VDDQ   POWER
B1   NF   NF_INPUT   252.00m   2.52nH   0.45pF
B2   VSSQ   GND
B3   DM   DM   161.00m   1.59nH   0.29pF
B7   DQS   DQ   169.00m   1.60nH   0.31pF
B8   VSSQ   GND
B9   NF   NF_INPUT   295.00m   2.88nH   0.54pF
C1   VDDQ   POWER
C2   DQ1   DQ   181.00m   1.54nH   0.33pF
C3   VDDQ   POWER
C7   VDDQ   POWER
C8   DQ0   DQ   274.00m   2.74nH   0.48pF
C9   VDDQ   POWER
D1   NF   NF_INPUT   207.00m   2.24nH   0.35pF
D2   VSSQ   GND
D3   DQ3   DQ   135.00m   1.29nH   0.24pF
D7   DQ2   DQ   149.00m   1.29nH   0.26pF
D8   VSSQ   GND
D9   NF   NF_INPUT   229.00m   2.08nH   0.43pF
E1   VDDL   POWER
E2   Vref   POWER
E3   VSS   GND
E7   VSSDL   GND
E8   CK   CLKIN   204.00m   1.85nH   0.36pF
E9   VDD   POWER
F2   CKE   INPUT   182.00m   2.09nH   0.32pF
F3   WE#   INPUT   148.00m   1.57nH   0.26pF
F7   RAS#   INPUT   156.00m   1.61nH   0.28pF
F8   CK#   CLKIN   198.00m   2.06nH   0.36pF
F9   ODT   INPUT   219.00m   2.60nH   0.38pF
G1   BA2   INPUT   212.00m   2.56nH   0.36pF
G2   BA0   INPUT   194.00m   2.23nH   0.34pF
G3   BA1   INPUT   155.00m   1.69nH   0.27pF
G7   CAS#   INPUT   144.00m   1.47nH   0.26pF
G8   CS#   INPUT   189.00m   2.14nH   0.33pF
H2   A10   INPUT   180.00m   2.02nH   0.33pF
H3   A1   INPUT   143.00m   1.47nH   0.24pF
H7   A2   INPUT   143.00m   1.35nH   0.25pF
H8   A0   INPUT   183.00m   1.77nH   0.32pF
H9   VDD   POWER
J1   VSS   GND
J2   A3   INPUT   175.00m   1.66nH   0.31pF
J3   A5   INPUT   137.00m   1.40nH   0.23pF
J7   A6   INPUT   132.00m   1.44nH   0.22pF
J8   A4   INPUT   166.00m   1.92nH   0.27pF
K2   A7   INPUT   159.00m   1.87nH   0.25pF
K3   A9   INPUT   126.00m   1.37nH   0.21pF
K7   A11   INPUT   123.00m   1.36nH   0.20pF
K8   A8   INPUT   157.00m   1.91nH   0.25pF
K9   VSS   GND
L1   VDD   POWER
L2   A12   INPUT   156.00m   1.95nH   0.22pF
L3   RFU   NC
L7   RFU   NC
L8   A13   INPUT   153.00m   1.93nH   0.20pF
|**********************DIFF PIN*********************************************
[Diff_pin]   inv_pin   vdiff   tdelay_typ   tdelay_min   tdelay_max
   E8   F8   .250V   0ns   NA   NA
   B7   A8   .250V   0ns   NA   NA
|  Pins B7 and A8 are a differential I/O only when DQS# is enabled via EMR
|  i.e EMR[E10]=0. If DQS# is disabled, then B7 (DQS) is a single ended I/O
|  and A8 is a NU
|   COMPONENT: MT47H256M4HQ_CLP (Common Landing Pattern)
[Component]  MT47H256M4HQ_CLP
[Package Model] U58A_8x10_clpx8
[Manufacturer]  Micron Technology,Inc.
[Package]
|   typ   min   max
R_pkg   178.43m   123.00m   295.00m
L_pkg   1.88nH   1.29nH   2.88nH
C_pkg   0.31pF   0.20pF   0.54pF
[Pin]   signal_name model_name   R_pin   L_pin   C_pin
H1   VDD   POWER
H2   NU_RDQS#   RDQS#   203.00m   2.29nH   0.38pF
H3   VSS   GND
H7   VSSQ   GND
H8   NU_DQS#   DQS#   213.00m   2.17nH   0.39pF
H9   VDDQ   POWER
J1   DQ6   DQ   252.00m   2.52nH   0.45pF
J2   VSSQ   GND
J3   DM_RDQS   DM_RDQS   161.00m   1.59nH   0.29pF
J7   DQS   DQ   169.00m   1.60nH   0.31pF
J8   VSSQ   GND
J9   DQ7   DQ   295.00m   2.88nH   0.54pF
K1   VDDQ   POWER
K2   DQ1   DQ   181.00m   1.54nH   0.33pF
K3   VDDQ   POWER
K7   VDDQ   POWER
K8   DQ0   DQ   274.00m   2.74nH   0.48pF
K9   VDDQ   POWER
L1   DQ4   DQ   207.00m   2.24nH   0.35pF
L2   VSSQ   GND
L3   DQ3   DQ   135.00m   1.29nH   0.24pF
L7   DQ2   DQ   149.00m   1.29nH   0.26pF
L8   VSSQ   GND
L9   DQ5   DQ   229.00m   2.08nH   0.43pF
M1   VDDL   POWER
M2   Vref   POWER
M3   VSS   GND
M7   VSSDL   GND
M8   CK   CLKIN   204.00m   1.85nH   0.36pF
M9   VDD   POWER
N2   CKE   INPUT   182.00m   2.09nH   0.32pF
N3   WE#   INPUT   148.00m   1.57nH   0.26pF
N7   RAS#   INPUT   156.00m   1.61nH   0.28pF
N8   CK#   CLKIN   198.00m   2.06nH   0.36pF
N9   ODT   INPUT   219.00m   2.60nH   0.38pF
P1   BA2   INPUT   212.00m   2.56nH   0.36pF
P2   BA0   INPUT   194.00m   2.23nH   0.34pF
P3   BA1   INPUT   155.00m   1.69nH   0.27pF
P7   CAS#   INPUT   144.00m   1.47nH   0.26pF
P8   CS#   INPUT   189.00m   2.14nH   0.33pF
R2   A10   INPUT   180.00m   2.02nH   0.33pF
R3   A1   INPUT   143.00m   1.47nH   0.24pF
R7   A2   INPUT   143.00m   1.35nH   0.25pF
R8   A0   INPUT   183.00m   1.77nH   0.32pF
R9   VDD   POWER
T1   VSS   GND
T2   A3   INPUT   175.00m   1.66nH   0.31pF
T3   A5   INPUT   137.00m   1.40nH   0.23pF
T7   A6   INPUT   132.00m   1.44nH   0.22pF
T8   A4   INPUT   166.00m   1.92nH   0.27pF
U2   A7   INPUT   159.00m   1.87nH   0.25pF
U3   A9   INPUT   126.00m   1.37nH   0.21pF
U7   A11   INPUT   123.00m   1.36nH   0.20pF
U8   A8   INPUT   157.00m   1.91nH   0.25pF
U9   VSS   GND
V1   VDD   POWER
V2   A12   INPUT   156.00m   1.95nH   0.22pF
V3   RFU   NC
V7   RFU   NC
V8   A13   INPUT   153.00m   1.93nH   0.20pF
|**********************DIFF PIN*********************************************
[Diff_pin]   inv_pin   vdiff   tdelay_typ   tdelay_min   tdelay_max
   M8   N8   .250V   0ns   NA   NA
   J7   H8   .250V   0ns   NA   NA
|  Pins J7 and H8 are a differential I/O only when DQS# is enabled via EMR
|  i.e EMR[E10]=0. If DQS# is disabled, then J7 (DQS) is a single ended I/O
|  and H8 is a NU
|   COMPONENT: MT47H128M8HQ (60-Ball FBGA, x8)
[Component]   MT47H128M8HQ
[Package Model] U58A_8x10_x8
[Manufacturer]  Micron Technology,Inc.
[Package]
|   typ   min   max
R_pkg   178.43m   123.00m   295.00m
L_pkg   1.88nH   1.29nH   2.88nH
C_pkg   0.31pF   0.20pF   0.54pF
[Pin]   signal_name model_name   R_pin   L_pin   C_pin
A1   VDD   POWER
A2   NU_RDQS#   RDQS#   203.00m   2.29nH   0.38pF
A3   VSS   GND
A7   VSSQ   GND
A8   NU_DQS#   DQS#   213.00m   2.17nH   0.39pF
A9   VDDQ   POWER
B1   DQ6   DQ   252.00m   2.52nH   0.45pF
B2   VSSQ   GND
B3   DM_RDQS   DM_RDQS   161.00m   1.59nH   0.29pF
B7   DQS   DQ   169.00m   1.60nH   0.31pF
B8   VSSQ   GND
B9   DQ7   DQ   295.00m   2.88nH   0.54pF
C1   VDDQ   POWER
C2   DQ1   DQ   181.00m   1.54nH   0.33pF
C3   VDDQ   POWER
C7   VDDQ   POWER
C8   DQ0   DQ   274.00m   2.74nH   0.48pF
C9   VDDQ   POWER
D1   DQ4   DQ   207.00m   2.24nH   0.35pF
D2   VSSQ   GND
D3   DQ3   DQ   135.00m   1.29nH   0.24pF
D7   DQ2   DQ   149.00m   1.29nH   0.26pF
D8   VSSQ   GND
D9   DQ5   DQ   229.00m   2.08nH   0.43pF
E1   VDDL   POWER
E2   Vref   POWER
E3   VSS   GND
E7   VSSDL   GND
E8   CK   CLKIN   204.00m   1.85nH   0.36pF
E9   VDD   POWER
F2   CKE   INPUT   182.00m   2.09nH   0.32pF
F3   WE#   INPUT   148.00m   1.57nH   0.26pF
F7   RAS#   INPUT   156.00m   1.61nH   0.28pF
F8   CK#   CLKIN   198.00m   2.06nH   0.36pF
F9   ODT   INPUT   219.00m   2.60nH   0.38pF
G1   BA2   INPUT   212.00m   2.56nH   0.36pF
G2   BA0   INPUT   194.00m   2.23nH   0.34pF
G3   BA1   INPUT   155.00m   1.69nH   0.27pF
G7   CAS#   INPUT   144.00m   1.47nH   0.26pF
G8   CS#   INPUT   189.00m   2.14nH   0.33pF
H2   A10   INPUT   180.00m   2.02nH   0.33pF
H3   A1   INPUT   143.00m   1.47nH   0.24pF
H7   A2   INPUT   143.00m   1.35nH   0.25pF
H8   A0   INPUT   183.00m   1.77nH   0.32pF
H9   VDD   POWER
J1   VSS   GND
J2   A3   INPUT   175.00m   1.66nH   0.31pF
J3   A5   INPUT   137.00m   1.40nH   0.23pF
J7   A6   INPUT   132.00m   1.44nH   0.22pF
J8   A4   INPUT   166.00m   1.92nH   0.27pF
K2   A7   INPUT   159.00m   1.87nH   0.25pF
K3   A9   INPUT   126.00m   1.37nH   0.21pF
K7   A11   INPUT   123.00m   1.36nH   0.20pF
K8   A8   INPUT   157.00m   1.91nH   0.25pF
K9   VSS   GND
L1   VDD   POWER
L2   A12   INPUT   156.00m   1.95nH   0.22pF
L3   RFU   NC
L7   RFU   NC
L8   A13   INPUT   153.00m   1.93nH   0.20pF
|**********************DIFF PIN*********************************************
[Diff_pin]   inv_pin   vdiff   tdelay_typ   tdelay_min   tdelay_max
   E8   F8   .250V   0ns   NA   NA
   B7   A8   .250V   0ns   NA   NA
   B3   A2   .250V   0ns   NA   NA
|  Pins B7 and A8 are a differential I/O only when DQS# is enabled via EMR
|  i.e EMR[E10]=0. If DQS# is disabled, then B7 (DQS) is a single ended I/O
|  and A8 is a NU
|  Pins B3 and A2 (RDQS, RDQS#) are differential output when RDQS enabled via
|  EMR command bit E11=0 and RDQS# is enabled via both EMR setting (E10=0,
|  DQS#enable and E11=1, RDQS enabled). When RDQS disbaled it becomes DM and
| when RDQS# disabled it becomes NU.
|   COMPONENT: MT47H128M8HQ_CLP (Common Landing Pattern)
[Component]  MT47H128M8HQ_CLP
[Package Model] U58A_8x10_clpx8
[Manufacturer]  Micron Technology,Inc.
[Package]
|   typ   min   max
R_pkg   178.43m   123.00m   295.00m
L_pkg   1.88nH   1.29nH   2.88nH
C_pkg   0.31pF   0.20pF   0.54pF
[Pin]   signal_name model_name   R_pin   L_pin   C_pin
H1   VDD   POWER
H2   NU_RDQS#   RDQS#   203.00m   2.29nH   0.38pF
H3   VSS   GND
H7   VSSQ   GND
H8   NU_DQS#   DQS#   213.00m   2.17nH   0.39pF
H9   VDDQ   POWER
J1   DQ6   DQ   252.00m   2.52nH   0.45pF
J2   VSSQ   GND
J3   DM_RDQS   DM_RDQS   161.00m   1.59nH   0.29pF
J7   DQS   DQ   169.00m   1.60nH   0.31pF
J8   VSSQ   GND
J9   DQ7   DQ   295.00m   2.88nH   0.54pF
K1   VDDQ   POWER
K2   DQ1   DQ   181.00m   1.54nH   0.33pF
K3   VDDQ   POWER
K7   VDDQ   POWER
K8   DQ0   DQ   274.00m   2.74nH   0.48pF
K9   VDDQ   POWER
L1   DQ4   DQ   207.00m   2.24nH   0.35pF
L2   VSSQ   GND
L3   DQ3   DQ   135.00m   1.29nH   0.24pF
L7   DQ2   DQ   149.00m   1.29nH   0.26pF
L8   VSSQ   GND
L9   DQ5   DQ   229.00m   2.08nH   0.43pF
M1   VDDL   POWER
M2   Vref   POWER
M3   VSS   GND
M7   VSSDL   GND
M8   CK   CLKIN   204.00m   1.85nH   0.36pF
M9   VDD   POWER
N2   CKE   INPUT   182.00m   2.09nH   0.32pF
N3   WE#   INPUT   148.00m   1.57nH   0.26pF
N7   RAS#   INPUT   156.00m   1.61nH   0.28pF
N8   CK#   CLKIN   198.00m   2.06nH   0.36pF
N9   ODT   INPUT   219.00m   2.60nH   0.38pF
P1   BA2   INPUT   212.00m   2.56nH   0.36pF
P2   BA0   INPUT   194.00m   2.23nH   0.34pF
P3   BA1   INPUT   155.00m   1.69nH   0.27pF
P7   CAS#   INPUT   144.00m   1.47nH   0.26pF
P8   CS#   INPUT   189.00m   2.14nH   0.33pF
R2   A10   INPUT   180.00m   2.02nH   0.33pF
R3   A1   INPUT   143.00m   1.47nH   0.24pF
R7   A2   INPUT   143.00m   1.35nH   0.25pF
R8   A0   INPUT   183.00m   1.77nH   0.32pF
R9   VDD   POWER
T1   VSS   GND
T2   A3   INPUT   175.00m   1.66nH   0.31pF
T3   A5   INPUT   137.00m   1.40nH   0.23pF
T7   A6   INPUT   132.00m   1.44nH   0.22pF
T8   A4   INPUT   166.00m   1.92nH   0.27pF
U2   A7   INPUT   159.00m   1.87nH   0.25pF
U3   A9   INPUT   126.00m   1.37nH   0.21pF
U7   A11   INPUT   123.00m   1.36nH   0.20pF
U8   A8   INPUT   157.00m   1.91nH   0.25pF
U9   VSS   GND
V1   VDD   POWER
V2   A12   INPUT   156.00m   1.95nH   0.22pF
V3   RFU   NC
V7   RFU   NC
V8   A13   INPUT   153.00m   1.93nH   0.20pF
|**********************DIFF PIN*********************************************
[Diff_pin]   inv_pin   vdiff   tdelay_typ   tdelay_min   tdelay_max
   M8   N8   .250V   0ns   NA   NA
   J7   H8   .250V   0ns   NA   NA
   J3   H2   .250V   0ns   NA   NA
|  Pins J7 and H8 are a differential I/O only when DQS# is enabled via EMR
|  i.e EMR[E10]=0. If DQS# is disabled, then J7 (DQS) is a single ended I/O
|  and H8 is a NU
|  Pins J3 and H2 (RDQS, RDQS#) are differential output when RDQS enabled via
|  EMR command bit E11=0 and RDQS# is enabled via both EMR setting (E10=0,
|  DQS#enable and E11=1, RDQS enabled). When RDQS disbaled it becomes DM and
| when RDQS# disabled it becomes NU.
|   Model Selector
[Model Selector] RDQS#
NF_INPUT   Not Used if either RDQS or Diff. Strobe are disabled
RDQS_FULL_533   Full-Drv Output Drvr with no ODT (400/533 Mbps)
RDQS_HALF_533   Reduced-Drv Output Drvr with no ODT (400/533 Mbps)
RDQS_FULL_800   Full-Drv Output Drvr with no ODT (667/800 Mbps)
RDQS_HALF_800   Reduced-Drv Output Drvr with no ODT (667/800 Mbps)
[Model Selector] DM_RDQS
DM_INPUT_533   DM input model with no ODT (400/533 Mbps)
DM_ODT50_533   DM Input model with 50 Ohm ODT Submodel (400/533 Mbps)
DM_ODT75_533   DM Input model with 75 Ohm ODT Submodel(400/533 Mbps)
DM_ODT150_533   DM Input model with 150 Ohm ODT Submodel (400/533 Mbps)
RDQS_FULL_533   Full-Drv Output Drvr if RDQS is enabled (400/533 Mbps)
RDQS_HALF_533   Reduced-Drv Output Drvr if RDQS is enabled (400/533 Mbps)
DM_INPUT_800   DM input model with no ODT (667/800 Mbps)
DM_ODT50_800   DM Input model with 50 Ohm ODT Submodel (667/800 Mbps)
DM_ODT75_800   DM Input model with 75 Ohm ODT Submodel (667/800 Mbps)
DM_ODT150_800   DM Input model with 150 Ohm ODT Submodel (667/800 Mbps)
RDQS_FULL_800   Full-Drv Output Drvr if RDQS is enabled (667/800 Mbps)
RDQS_HALF_800   Reduced-Drv Output Drvr if RDQS is enabled (667/800 Mbps)
|   COMPONENT: MT47H64M16HR (84-Ball FBGA, x16)
[Component]   MT47H64M16HR
[Package Model] U58A_8x12p5_x16
[Manufacturer]  Micron Technology,Inc.
[Package]
|   typ   min   max
R_pkg   176.36m   113.00m   279.00m
L_pkg   1.82nH   1.08nH   2.81nH
C_pkg   0.30pF   0.21pF   0.47pF
[Pin]   signal_name model_name   R_pin   L_pin   C_pin
A1   VDD   POWER
A2   NC   NC
A3   VSS   GND
A7   VSSQ   GND
A8   UDQS#_NU   DQS#   199.00m   2.04nH   0.37pF
A9   VDDQ   POWER
B1   DQ14   DQ   231.00m   2.51nH   0.37pF
B2   VSSQ   GND
B3   UDM   DM   129.00m   1.21nH   0.27pF
B7   UDQS   DQ   151.00m   1.43nH   0.28pF
B8   VSSQ   GND
B9   DQ15   DQ   279.00m   2.41nH   0.47pF
C1   VDDQ   POWER
C2   DQ9   DQ   174.00m   2.81nH   0.28pF
C3   VDDQ   POWER
C7   VDDQ   POWER
C8   DQ8   DQ   257.00m   2.35nH   0.42pF
C9   VDDQ   POWER
D1   DQ12   DQ   199.00m   2.02nH   0.34pF
D2   VSSQ   GND
D3   DQ11   DQ   131.00m   1.14nH   0.21pF
D7   DQ10   DQ   136.00m   1.09nH   0.25pF
D8   VSSQ   GND
D9   DQ13   DQ   226.00m   1.94nH   0.41pF
E1   VDD   POWER
E2   NC   NC   165.00m   1.76nH   0.28pF
E3   VSS   GND
E7   VSSQ   GND
E8   LDQS#_NU   DQS#   162.00m   1.63nH   0.28pF
E9   VDDQ   POWER
F1   DQ6   DQ   238.00m   1.86nH   0.36pF
F2   VSSQ   GND
F3   LDM   DM   137.00m   1.28nH   0.24pF
F7   LDQS   DQ   129.00m   1.18nH   0.21pF
F8   VSSQ   GND
F9   DQ7   DQ   242.00m   2.01nH   0.42pF
G1   VDDQ   POWER
G2   DQ1   DQ   169.00m   1.59nH   0.26pF
G3   VDDQ   POWER
G7   VDDQ   POWER
G8   DQ0   DQ   231.00m   2.33nH   0.38pF
G9   VDDQ   POWER
H1   DQ4   DQ   218.00m   1.08nH   0.35pF
H2   VSSQ   GND
H3   DQ3   DQ   132.00m   1.51nH   0.22pF
H7   DQ2   DQ   132.00m   2.65nH   0.24pF
H8   VSSQ   GND
H9   DQ5   DQ   206.00m   1.17nH   0.37pF
J1   VDDL   POWER
J2   Vref   POWER
J3   VSS   GND
J7   VSSDL   GND
J8   CK   CLKIN   171.00m   1.74nH   0.26pF
J9   VDD   POWER
K2   CKE   INPUT   186.00m   2.06nH   0.28pF
K3   WE#   INPUT   132.00m   1.29nH   0.22pF
K7   RAS#   INPUT   113.00m   1.20nH   0.22pF
K8   CK#   CLKIN   158.00m   1.74nH   0.27pF
K9   ODT   INPUT   208.00m   2.49nH   0.32pF
L1   BA2   INPUT   224.00m   2.64nH   0.36pF
L2   BA0   INPUT   172.00m   1.91nH   0.30pF
L3   BA1   INPUT   126.00m   1.35nH   0.26pF
L7   CAS   INPUT   136.00m   1.39nH   0.21pF
L8   CS#   INPUT   164.00m   1.86nH   0.28pF
M2   A10   INPUT   180.00m   2.03nH   0.30pF
M3   A1   INPUT   136.00m   1.39nH   0.22pF
M7   A2   INPUT   132.00m   1.25nH   0.24pF
M8   A0   INPUT   169.00m   1.75nH   0.28pF
M9   VDD   POWER
N1   VSS   GND
N2   A3   INPUT   183.00m   1.74nH   0.32pF
N3   A5   INPUT   148.00m   1.51nH   0.27pF
N7   A6   INPUT   144.00m   1.60nH   0.26pF
N8   A4   INPUT   182.00m   2.05nH   0.28pF
P2   A7   INPUT   194.00m   2.25nH   0.32pF
P3   A9   INPUT   165.00m   1.80nH   0.30pF
P7   A11   INPUT   161.00m   1.80nH   0.29pF
P8   A8   INPUT   189.00m   2.27nH   0.31pF
P9   VSS   GND
R1   VDD   POWER
R2   A12   INPUT   207.00m   2.51nH   0.31pF
R3   RFU   NC
R7   RFU   NC
R8   A13   INPUT   201.00m   2.50nH   0.31pF
|**********************DIFF PIN*********************************************
[Diff_pin]   inv_pin   vdiff   tdelay_typ   tdelay_min   tdelay_max
   B7   A8   .250V   0ns   NA   NA
   F7   E8   .250V   0ns   NA   NA
   J8   K8   .250V   0ns   NA   NA
|  Pins B7 and A8 are a differential I/O only when UDQS# is enabled via EMR
|  If UDQS# is disabled, then B7 (UDQS) is a single ended I/O and A8 is a NU
|  Pins F7 and E8 are a differential I/O only when LDQS# is enabled via EMR
|  If LDQS# is disabled, then E8 (LDQS) is a single ended I/O and F7 is a NU
|   COMPONENT: MT47H64M16HR_CLP (Common Landing Pattern)
[Component]  MT47H64M16HR_CLP
[Package Model] U58A_8x12p5_clpx16
[Manufacturer]  Micron Technology,Inc.
[Package]
|   typ   min   max
R_pkg   176.36m   113.00m   279.00m
L_pkg   1.82nH   1.08nH   2.81nH
C_pkg   0.30pF   0.21pF   0.47pF
[Pin]   signal_name model_name   R_pin   L_pin   C_pin
D1   VDD   POWER
D2   NC   NC
D3   VSS   GND
D7   VSSQ   GND
D8   UDQS#_NU   DQS#   199.00m   2.04nH   0.37pF
D9   VDDQ   POWER
E1   DQ14   DQ   231.00m   2.51nH   0.37pF
E2   VSSQ   GND
E3   UDM   DM   129.00m   1.21nH   0.27pF
E7   UDQS   DQ   151.00m   1.43nH   0.28pF
E8   VSSQ   GND
E9   DQ15   DQ   279.00m   2.41nH   0.47pF
F1   VDDQ   POWER
F2   DQ9   DQ   174.00m   2.81nH   0.28pF
F3   VDDQ   POWER
F7   VDDQ   POWER
F8   DQ8   DQ   257.00m   2.35nH   0.42pF
F9   VDDQ   POWER
G1   DQ12   DQ   199.00m   2.02nH   0.34pF
G2   VSSQ   GND
G3   DQ11   DQ   131.00m   1.14nH   0.21pF
G7   DQ10   DQ   136.00m   1.09nH   0.25pF
G8   VSSQ   GND
G9   DQ13   DQ   226.00m   1.94nH   0.41pF
H1   VDD   POWER
H2   NC   NC   165.00m   1.76nH   0.28pF
H3   VSS   GND
H7   VSSQ   GND
H8   LDQS#_NU   DQS#   162.00m   1.63nH   0.28pF
H9   VDDQ   POWER
J1   DQ6   DQ   238.00m   1.86nH   0.36pF
J2   VSSQ   GND
J3   LDM   DM   137.00m   1.28nH   0.24pF
J7   LDQS   DQ   129.00m   1.18nH   0.21pF
J8   VSSQ   GND
J9   DQ7   DQ   242.00m   2.01nH   0.42pF
K1   VDDQ   POWER
K2   DQ1   DQ   169.00m   1.59nH   0.26pF
K3   VDDQ   POWER
K7   VDDQ   POWER
K8   DQ0   DQ   231.00m   2.33nH   0.38pF
K9   VDDQ   POWER
L1   DQ4   DQ   218.00m   1.08nH   0.35pF
L2   VSSQ   GND
L3   DQ3   DQ   132.00m   1.51nH   0.22pF
L7   DQ2   DQ   132.00m   2.65nH   0.24pF
L8   VSSQ   GND
L9   DQ5   DQ   206.00m   1.17nH   0.37pF
M1   VDDL   POWER
M2   Vref   POWER
M3   VSS   GND
M7   VSSDL   GND
M8   CK   CLKIN   171.00m   1.74nH   0.26pF
M9   VDD   POWER
N2   CKE   INPUT   186.00m   2.06nH   0.28pF
N3   WE#   INPUT   132.00m   1.29nH   0.22pF
N7   RAS#   INPUT   113.00m   1.20nH   0.22pF
N8   CK#   CLKIN   158.00m   1.74nH   0.27pF
N9   ODT   INPUT   208.00m   2.49nH   0.32pF
P1   BA2   INPUT   224.00m   2.64nH   0.36pF
P2   BA0   INPUT   172.00m   1.91nH   0.30pF
P3   BA1   INPUT   126.00m   1.35nH   0.26pF
P7   CAS   INPUT   136.00m   1.39nH   0.21pF
P8   CS#   INPUT   164.00m   1.86nH   0.28pF
R2   A10   INPUT   180.00m   2.03nH   0.30pF
R3   A1   INPUT   136.00m   1.39nH   0.22pF
R7   A2   INPUT   132.00m   1.25nH   0.24pF
R8   A0   INPUT   169.00m   1.75nH   0.28pF
R9   VDD   POWER
T1   VSS   GND
T2   A3   INPUT   183.00m   1.74nH   0.32pF
T3   A5   INPUT   148.00m   1.51nH   0.27pF
T7   A6   INPUT   144.00m   1.60nH   0.26pF
T8   A4   INPUT   182.00m   2.05nH   0.28pF
U2   A7   INPUT   194.00m   2.25nH   0.32pF
U3   A9   INPUT   165.00m   1.80nH   0.30pF
U7   A11   INPUT   161.00m   1.80nH   0.29pF
U8   A8   INPUT   189.00m   2.27nH   0.31pF
U9   VSS   GND
V1   VDD   POWER
V2   A12   INPUT   207.00m   2.51nH   0.31pF
V3   RFU   NC
V7   RFU   NC
V8   A13   INPUT   201.00m   2.50nH   0.31pF
|**********************DIFF PIN*********************************************
[Diff_pin]   inv_pin   vdiff   tdelay_typ   tdelay_min   tdelay_max
   M8   N8   .250V   0ns   NA   NA
   J7   H8   .250V   0ns   NA   NA
   E7   D8   .250V   0ns   NA   NA
|  Pins J7 and H8 are a differential I/O only when LDQS# is enabled via EMR
|  If LDQS# is disabled, then J7 (LDQS) is a single ended I/O and H8 is a NU
|  Pins E7 and D8 are a differential I/O only when UDQS# is enabled via EMR
|  If UDQS# is disabled, then E7 (UDQS) is a single ended I/O and D8 is a NU
|   COMPONENT: MT47H256M4U58A (Bare Die x4)
[Component]   MT47H256M4U58A
[Manufacturer]  Micron Technology,Inc.
[Package]
|   typ   min   max
R_pkg   0.001m  0.001m  0.001m
L_pkg   0.001nH 0.001nH 0.001nH
C_pkg   0.001pf 0.001pf 0.001pf
[Pin]   signal_name   model_name   R_pin   L_pin   C_pin
1   VSS   GND
2   VDD   POWER
3   VSS   GND
4   VDD   POWER
5   DNU   NC
6   DNU   NC
7   VDDQ   POWER
8   VSSQ   GND
9   DNU   NC
10   DNU   NC
11   VSSQ   GND
12   VDDQ   POWER
13   DNU   NC
14   DNU   NC
15   VSSQ   GND
16   VDDQ   POWER
17   DNU   NC
18   DNU   NC
19   VSSQ   GND
20   VDDQ   POWER
21   DNU   NC
22   DNU   NC
23   VSSQ   GND
24   VDDQ   POWER
25   DNU   NC
26   VSS   GND
27   DNU   NC
28   VDD   POWER
29   DM   DM
30   DNU   NC
31   VDDQ   POWER
32   VSSQ   GND
33   DNU   NC
34   DQS#   DQS#
35   VSSQ   GND
36   VDDQ   POWER
37   DQS   DQ
38   DQ0   DQ
39   VSSQ   GND
40   VDDQ   POWER
41   DQ1   DQ
42   DNU   NC
43   VSSQ   GND
44   VDDQ   POWER
45   DQ2   DQ
46   DQ3   DQ
47   VSSQ   GND
48   VDDQ   POWER
49   DNU   NC
50   VDD   POWER
51   VSS   GND
52   VSS   GND
53   VDD   POWER
54   VSS   GND
55   VDD   POWER
56   DNU   NC
57   Vref   POWER
58   VDDL   POWER
59   VSSDL   GND
60   CK   CLKIN
61   CK#   CLKIN
62   WE#   INPUT
63   CKE   INPUT
64   RAS#   INPUT
65   ODT   INPUT
66   CS#   INPUT
67   CAS#   INPUT
68   BA0   INPUT
69   BA1   INPUT
70   BA2   INPUT
71   A10   INPUT
72   A0   INPUT
73   A1   INPUT
74   VSS   GND
75   VDD   POWER
76   A2   INPUT
77   A3   INPUT
78   A4   INPUT
79   A5   INPUT
80   A6   INPUT
81   A7   INPUT
82   A8   INPUT
83   A9   INPUT
84   A11   INPUT
85   A12   INPUT
86   A13   INPUT
87   DNU   NC
88   DNU   NC
89   VDD   POWER
90   VSS   GND
91   VDD   POWER
92   VSS   GND
93   DNU   NC
94   DNU   NC
95   VBB   POWER
|**********************DIFF PIN*********************************************
[Diff_pin]   inv_pin   vdiff   tdelay_typ   tdelay_min   tdelay_max
   60   61   .250V   0ns   NA   NA
   37   34   .250V   0ns   NA   NA
|  Pins 37 and 34 are a differential I/O only when DQS# is enabled via EMR
|  i.e EMR[E10]=0. If DQS# is disabled, then 37 (DQS) is a single ended I/O
|  and 34 is a NU
|   COMPONENT: MT47H128M8U58A (Bare Die x8)
[Component]   MT47H128M8U58A
[Manufacturer]  Micron Technology,Inc.
[Package]
|   typ   min   max
R_pkg   0.001m  0.001m  0.001m
L_pkg   0.001nH 0.001nH 0.001nH
C_pkg   0.001pf 0.001pf 0.001pf
[Pin]   signal_name model_name   R_pin   L_pin   C_pin
1   VSS   GND
2   VDD   POWER
3   VSS   GND
4   VDD   POWER
5   DNU   NC
6   DNU   NC
7   VDDQ   POWER
8   VSSQ   GND
9   DNU   NC
10   DNU   NC
11   VSSQ   GND
12   VDDQ   POWER
13   DNU   NC
14   DNU   NC
15   VSSQ   GND
16   VDDQ   POWER
17   DNU   NC
18   DNU   NC
19   VSSQ   GND
20   VDDQ   POWER
21   DNU   NC
22   DNU   NC
23   VSSQ   GND
24   VDDQ   POWER
25   DNU   NC
26   VSS   GND
27   RDQS#   RDQS#
28   VDD   POWER
29   DM/RDQS   DM_RDQS
30   DQ6   DQ
31   VDDQ   POWER
32   VSSQ   GND
33   DQ7   DQ
34   DQS#   DQS#
35   VSSQ   GND
36   VDDQ   POWER
37   DQS   DQ
38   DQ0   DQ
39   VSSQ   GND
40   VDDQ   POWER
41   DQ1   DQ
42   DQ5   DQ
43   VSSQ   GND
44   VDDQ   POWER
45   DQ2   DQ
46   DQ3   DQ
47   VSSQ   GND
48   VDDQ   POWER
49   DQ4   DQ
50   VDD   POWER
51   VSS   GND
52   VSS   GND
53   VDD   POWER
54   VSS   GND
55   VDD   POWER
56   DNU   NC
57   Vref   POWER
58   VDDL   POWER
59   VSSDL   GND
60   CK   CLKIN
61   CK#   CLKIN
62   WE#   INPUT
63   CKE   INPUT
64   RAS#   INPUT
65   ODT   INPUT
66   CS#   INPUT
67   CAS#   INPUT
68   BA0   INPUT
69   BA1   INPUT
70   BA2   INPUT
71   A10   INPUT
72   A0   INPUT
73   A1   INPUT
74   VSS   GND
75   VDD   POWER
76   A2   INPUT
77   A3   INPUT
78   A4   INPUT
79   A5   INPUT
80   A6   INPUT
81   A7   INPUT
82   A8   INPUT
83   A9   INPUT
84   A11   INPUT
85   A12   INPUT
86   A13   INPUT
87   DNU   NC
88   DNU   NC
89   VDD   POWER
90   VSS   GND
91   VDD   POWER
92   VSS   GND
93   DNU   NC
94   DNU   NC
95   VBB   POWER
|**********************DIFF PIN*********************************************
[Diff_pin]   inv_pin   vdiff   tdelay_typ   tdelay_min   tdelay_max
   60   61   .250V   0ns   NA   NA
   37   34   .250V   0ns   NA   NA
   29   27   .250V   0ns   NA   NA
|  Pins 37 and 34 are a differential I/O only when DQS# is enabled via EMR
|  i.e EMR[E10]=0. If DQS# is disabled, then 37 (DQS) is a single ended I/O
|  and 34 is a NU
|  Pins 29 and 27 (RDQS, RDQS#) are differential output when RDQS enabled via
|  EMR command bit E11=0 and RDQS# is enabled via both EMR setting (E10=0,
|  DQS#enable and E11=1, RDQS enabled). When RDQS disbaled it becomes DM and
| when RDQS# disabled it becomes NU.
|   COMPONENT: MT47H64M16U58A (Bare Die x16)
[Component]   MT47H64M16U58A
[Manufacturer]  Micron Technology,Inc.
[Package]
|   typ   min   max
R_pkg   0.001m  0.001m  0.001m
L_pkg   0.001nH 0.001nH 0.001nH
C_pkg   0.001pf 0.001pf 0.001pf
[Pin]   signal_name model_name   R_pin   L_pin   C_pin
1   VSS   GND
2   VDD   POWER
3   VSS   GND
4   VDD   POWER
5   UDM   DM
6   DQ14   DQ
7   VDDQ   POWER
8   VSSQ   GND
9   DQ15   DQ
10   UDQS#   DQS#
11   VSSQ   GND
12   VDDQ   POWER
13   UDQS   DQ
14   DQ8   DQ
15   VSSQ   GND
16   VDDQ   POWER
17   DQ9   DQ
18   DQ13   DQ
19   VSSQ   GND
20   VDDQ   POWER
21   DQ10   DQ
22   DQ11   DQ
23   VSSQ   GND
24   VDDQ   POWER
25   DQ12   DQ
26   VSS   GND
27   DNU   NC
28   VDD   POWER
29   LDM   DM
30   DQ6   DQ
31   VDDQ   POWER
32   VSSQ   GND
33   DQ7   DQ
34   LDQS#   DQS#
35   VSSQ   GND
36   VDDQ   POWER
37   LDQS   DQ
38   DQ0   DQ
39   VSSQ   GND
40   VDDQ   POWER
41   DQ1   DQ
42   DQ5   DQ
43   VSSQ   GND
44   VDDQ   POWER
45   DQ2   DQ
46   DQ3   DQ
47   VSSQ   GND
48   VDDQ   POWER
49   DQ4   DQ
50   VDD   POWER
51   VSS   GND
52   VSS   GND
53   VDD   POWER
54   VSS   GND
55   VDD   POWER
56   DNU   NC
57   Vref   POWER
58   VDDL   POWER
59   VSSDL   GND
60   CK   CLKIN
61   CK#   CLKIN
62   WE#   INPUT
63   CKE   INPUT
64   RAS#   INPUT
65   ODT   INPUT
66   CS#   INPUT
67   CAS#   INPUT
68   BA0   INPUT
69   BA1   INPUT
70   BA2   INPUT
71   A10   INPUT
72   A0   INPUT
73   A1   INPUT
74   VSS   GND
75   VDD   POWER
76   A2   INPUT
77   A3   INPUT
78   A4   INPUT
79   A5   INPUT
80   A6   INPUT
81   A7   INPUT
82   A8   INPUT
83   A9   INPUT
84   A11   INPUT
85   A12   INPUT
86   DNU   NC
87   DNU   NC
88   DNU   NC
89   VDD   POWER
90   VSS   GND
91   VDD   POWER
92   VSS   GND
93   DNU   NC
94   DNU   NC
95   VBB   POWER
|**********************DIFF PIN*********************************************
[Diff_pin]   inv_pin   vdiff   tdelay_typ   tdelay_min   tdelay_max
   60   61   .250V   0ns   NA   NA
   37   34   .250V   0ns   NA   NA
   13   10   .250V   0ns   NA   NA
|  Pins 37 and 38 are a differential I/O only when LDQS# is enabled via EMR
|  If LDQS# is disabled, then 37 (LDQS) is a single ended I/O and 34 is a NU
|  Pins 13 and 10 are a differential I/O only when UDQS# is enabled via EMR
|  If UDQS# is disabled, then 13 (UDQS) is a single ended I/O and 10 is a NU
|   Model Selector
[Model Selector] DM
DM_INPUT_533   DM input model with no ODT
DM_ODT150_533   DM Input model with 150 Ohm ODT Submodel
DM_ODT50_533   DM Input model with 50 Ohm ODT Submodel
DM_ODT75_533   DM Input model with 75 Ohm ODT Submodel
DM_INPUT_800   DM input model with no ODT (667/800 Mbps)
DM_ODT50_800   DM Input model with 50 Ohm ODT Submodel (667/800 Mbps)
DM_ODT75_800   DM Input model with 75 Ohm ODT Submodel (667/800 Mbps)
DM_ODT150_800   DM Input model with 150 Ohm ODT Submodel (667/800 Mbps)
[Model Selector] DQ
DQFULL_533   Full-Drv IO Drvr with no ODT
DQFULL_ODT150_533   Full-Drv IO Drvr with 150 Ohm ODT Submodel
DQFULL_ODT50_533   Full-Drv IO Drvr with 50 Ohm ODT Submodel
DQFULL_ODT75_533   Full-Drv IO Drvr with 75 Ohm ODT Submodel
DQHALF_533   Reduced-Drv IO Drvr with no ODT
DQHALF_ODT50_533   Reduced-Drv IO Drvr with 50 Ohm ODT Submodel
DQHALF_ODT75_533   Reduced-Drv IO Drvr with 75 Ohm ODT Submodel
DQHALF_ODT150_533   Reduced-Drv IO Drvr with 150 Ohm ODT Submodel
DQFULL_800   Full-Drv IO Drvr with no ODT (667/800 Mbps)
DQFULL_ODT50_800   Full-Drv IO Drvr with 50 Ohm ODT Submodel (667/800 Mbps)
DQFULL_ODT75_800   Full-Drv IO Drvr with 75 Ohm ODT Submodel (667/800 Mbps)
DQFULL_ODT150_800   Full-Drv IO Drvr with 150 Ohm ODT Submodel (667/800 Mbps)
DQHALF_800   Reduced-Drv IO Drvr with no ODT (667/800 Mbps)
DQHALF_ODT50_800   Reduced-Drv IO Drvr with 50 Ohm ODT Submodel (667/800 Mbps)
DQHALF_ODT75_800   Reduced-Drv IO Drvr with 75 Ohm ODT Submodel (667/800 Mbps)
DQHALF_ODT150_800   Reduced-Drv IO Drvr with 150 Ohm ODT Submodel (667/800 Mbps)
[Model Selector] DQS#
DQFULL_533   Full-Drv IO Drvr with no ODT (400/533 Mbps)
DQFULL_ODT150_533   Full-Drv IO Drvr with 150 Ohm ODT Submodel (400/533 Mbps)
DQFULL_ODT50_533   Full-Drv IO Drvr with 50 Ohm ODT Submodel(400/533 Mbps)
DQFULL_ODT75_533   Full-Drv IO Drvr with 75 Ohm ODT Submodel (400/533 Mbps)
DQHALF_533   Reduced-Drv IO Drvr with no ODT (400/533 Mbps)
DQHALF_ODT50_533   Reduced-Drv IO Drvr with 50 Ohm ODT Submodel (400/533 Mbps)
DQHALF_ODT75_533   Reduced-Drv IO Drvr with 75 Ohm ODT Submodel (400/533 Mbps)
DQHALF_ODT150_533   Reduced-Drv IO Drvr with 150 Ohm ODT Submodel(400/533 Mbps)
DQFULL_800   Full-Drv IO Drvr with no ODT (667/800 Mbps)
DQFULL_ODT50_800   Full-Drv IO Drvr with 50 Ohm ODT Submodel (667/800 Mbps)
DQFULL_ODT75_800   Full-Drv IO Drvr with 75 Ohm ODT Submodel (667/800 Mbps)
DQFULL_ODT150_800   Full-Drv IO Drvr with 150 Ohm ODT Submodel (667/800 Mbps)
DQHALF_800   Reduced-Drv IO Drvr with no ODT (667/800 Mbps)
DQHALF_ODT50_800   Reduced-Drv IO Drvr with 50 Ohm ODT Submodel (667/800 Mbps)
DQHALF_ODT75_800   Reduced-Drv IO Drvr with 75 Ohm ODT Submodel (667/800 Mbps)
DQHALF_ODT150_800   Reduced-Drv IO Drvr with 150 Ohm ODT Submodel(667/800 Mbps)
NF_INPUT   (Use to disable DQS#)
[Model Selector] INPUT
INPUT_533   Input Model for 400/533 Speed Grade (400/533 Mbps)
INPUT_800   Input Model for 667/800 Speed Grade (667/800 Mbps)
[Model Selector] CLKIN
CLKIN_533   Clock Input Model for 400/533 Speed Grade (400/533 Mbps)
CLKIN_800   Clock Input Model for 667/800 Speed Grade (667/800 Mbps)
[Define Package Model]   U58A_8x10_x8
[Manufacturer]   Micron Technology, Inc.
[OEM]   Micron Technology, Inc.
[Description]   8mm X 10mm
[Number of Pins]   55
[Pin Numbers]
A1
A2
A3
A7
A8
A9
B1
B2
B3
B7
B8
B9
C1
C2
C3
C7
C8
D1
D3
D7
D8
D9
E1
E2
E3
E7
E8
E9
F2
F3
F7
F8
F9
G1
G2
G3
G7
G8
H2
H3
H7
H8
J1
J2
J3
J7
J8
K2
K3
K7
K8
K9
L1
L2
L8
[Model Data]
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[End Model Data]
[End Package Model]
[Define Package Model]   U58A_8x12p5_x16
[Manufacturer]   Micron Technology, Inc.
[OEM]   Micron Technology, Inc.
[Description]   8mm X 12.5mm
[Number of Pins]   81
[Pin Numbers]
A1
A3
A7
A8
A9
B1
B2
B3
B7
B8
B9
C1
C2
C3
C7
C8
C9
D1
D2
D3
D7
D8
D9
E1
E2
E3
E7
E8
E9
F1
F2
F3
F7
F8
F9
G1
G2
G3
G7
G8
G9
H1
H2
H3
H7
H8
H9
J1
J2
J3
J7
J8
J9
K2
K3
K7
K8
K9
L1
L2
L3
L7
L8
M2
M3
M7
M8
M9
N1
N2
N3
N7
N8
P2
P3
P7
P8
P9
R1
R2
R8
[Model Data]
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[End Model Data]
[End Package Model]
[Define Package Model]   U58A_8x10_clpx8
[Manufacturer]   Micron Technology, Inc.
[OEM]   Micron Technology, Inc.
[Description]   8mm X 10mm
[Number of Pins]   55
[Pin Numbers]
H1
H2
H3
H7
H8
H9
J1
J2
J3
J7
J8
J9
K1
K2
K3
K7
K8
L1
L3
L7
L8
L9
M1
M2
M3
M7
M8
M9
N2
N3
N7
N8
N9
P1
P2
P3
P7
P8
R2
R3
R7
R8
T1
T2
T3
T7
T8
U2
U3
U7
U8
U9
V1
V2
V8
[Model Data]
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[End Model Data]
[End Package Model]
[Define Package Model]   U58A_8x12p5_clpx16
[Manufacturer]   Micron Technology, Inc.
[OEM]   Micron Technology, Inc.
[Description]   8mm X 12.5mm
[Number of Pins]   81
[Pin Numbers]
D1
D3
D7
D8
D9
E1
E2
E3
E7
E8
E9
F1
F2
F3
F7
F8
F9
G1
G2
G3
G7
G8
G9
H1
H2
H3
H7
H8
H9
J1
J2
J3
J7
J8
J9
K1
K2
K3
K7
K8
K9
L1
L2
L3
L7
L8
L9
M1
M2
M3
M7
M8
M9
N2
N3
N7
N8
N9
P1
P2
P3
P7
P8
R2
R3
R7
R8
R9
T1
T2
T3
T7
T8
U2
U3
U7
U8
U9
V1
V2
V8
[Model Data]
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[End Model Data]
[End Package Model]
| Models and submodels in the file (39): DQFULL_533 (I/O), DQFULL_ODT50_533 (I/O), DQFULL_ODT75_533 (I/O), DQFULL_ODT150_533 (I/O), DQHALF_533 (I/O), DQHALF_ODT50_533 (I/O), DQHALF_ODT75_533 (I/O), DQHALF_ODT150_533 (I/O), DQFULL_800 (I/O), DQFULL_ODT50_800 (I/O), DQFULL_ODT75_800 (I/O), DQFULL_ODT150_800 (I/O), DQHALF_800 (I/O), DQHALF_ODT50_800 (I/O), DQHALF_ODT75_800 (I/O), DQHALF_ODT150_800 (I/O), RDQS_FULL_533 (Output), RDQS_HALF_533 (Output), RDQS_FULL_800 (Output), RDQS_HALF_800 (Output), DM_INPUT_533 (Input), DM_ODT50_533 (Input), DM_ODT75_533 (Input), DM_ODT150_533 (Input), DM_INPUT_800 (Input), DM_ODT50_800 (Input), DM_ODT75_800 (Input), DM_ODT150_800 (Input), INPUT_533 (Input), INPUT_800 (Input), CLKIN_533 (Input), CLKIN_800 (Input), NF_INPUT (Terminator), 50ohm_ODT_533 (Dynamic_clamp), 75ohm_ODT_533 (Dynamic_clamp), 150ohm_ODT_533 (Dynamic_clamp), 50ohm_ODT_800 (Dynamic_clamp), 75ohm_ODT_800 (Dynamic_clamp), 150ohm_ODT_800 (Dynamic_clamp)

| TEXAS INSTRUMENTS INCORPORATED
| Standard Linear and Logic Group
| IBIS Model of SN74LVC244A
| OCTAL BUFFER/DRIVER WITH 3-STATE OUTPUTS
| This file contains package information for the following:
|  TSSOP 20-pin (PW) package as [Component] LVC244J_PW
|  TVSOP 20-pin (DGV) package as [Component] LVC244J_DGV
|  SOIC 20-pin (DW) package as [Component] LVC244J_DW
|  SSOP 20-pin (DB) package as [Component] LVC244J_DB
|  QFN 20-pin (RGY) package as [Component] LVC244J_RGY
|  PDIP 20-pin (N) package as [Component] LVC244J_N
|  SOP 20-pin (NS) package as [Component] LVC244J_NS
|  jrBGA 20-pin (GQN) package as [Component] LVC244J_GQN
|  jrBGA 20-pin (ZQN) package as [Component] LVC244J_ZQN
| This device can be powered at the following Vccs:
|  1.8 volt Vcc
|  2.5 volt Vcc
|  3.3 volt Vcc
| This file provides unique models under the [Model Selector] for each Vcc.
| For operation at a specific Vcc, select the appropriate model after each
| [Model Selector] keyword.
[IBIS Ver]   3.2
[Comment char]  |_char
[File Name]   SN74LVC244A_REVC.ibs
[File Rev]   1.4 | j_die
[Date]   November 27, 2007
[Source]   Data created from TI-SPICE simulations at TI-SLL.
[Notes]   The following is an IBIS list for the SN74LVC244A.
   Please contact sllibis@ti.com with questions and
   comments concerning SLL IBIS models.
   - FILE REV HISTORY
   - 1.2 added RGY, DGV, N, and NS packages 01/29/04
   - 1.3 added GQN and ZQN packages 08/09/04
   - 1.4 recreated die data with updated simulation data 11/27/07
   - Power clamp data deleted as there is no power-clamp diode.
   - Though we took all possible cautions, there are some
   Ramp End points mismatch warnings in this file.
   - Due to the fact that the Device is 5-V Input/Output
   tolarent, the Model has some Non-Monotonic Warnings.
[Disclaimer] Property of Texas Instruments Incorporated.  Unauthorized
                reproduction and/or distribution is strictly prohibited.
                This product is protected under copyright law.
                Created  2007, (C) Copyright  2007, Texas Instruments
                Incorporated, All Rights Reserved
                UNLESS THERE IS A SIGNED, WRITTEN AGREEMENT TO THE
                CONTRARY, TEXAS INSTRUMENTS (TI) IS PROVIDING THE IBIS
                MODELS  AND WITHOUT ANY WARRANTY, EXPRESSED OR
                IMPLIED.  TI assumes no liability for:
                 1) the accuracy of the IBIS models provided to your
                    company;
                 2) the proper functioning of these IBIS Models in your
                    design or for any resulting applications; or
                 3) infringement of patents, copyrights or intellectual
                    property rights resulting from your use of these IBIS
                    models.
                TI provides IBIS Models as a service to our customers.
                You and your company shall not distribute, sell or give
                these models to anyone else without prior written
                permission from TI.
                TI reserves the right to make changes to our products or
                to discontinue any semiconductor product or service
                without notice, and advises our customers to obtain the
                latest version of relevant information to verify, before
                placing orders, that the information being relied on is
                current.
                Please be aware that your receipt and use of the IBIS
                information provided shall serve as acceptance of these
                terms and conditions.  If you do not accept these terms,
                you should return or destroy the IBIS models and any
                other accompanying information immediately.
| Component SN74LVC244A_PW 20-PIN TSSOP
[Component]   SN74LVC244A_PW
[Manufacturer]   Texas Instruments, Inc.
[Package]
|   typ   min   max
R_pkg   5.000e-02   4.200e-02   6.000e-02
L_pkg   2.802e-09   2.248e-09   3.553e-09
C_pkg   3.170e-13   2.020e-13   4.430e-13
[Pin]   signal_name   model_name   R_pin   L_pin   C_pin
1   1NOE   LVC244A_NOE   5.500e-02   3.461e-09   4.400e-13
2   1A1   LVC244A_IN   5.500e-02   3.150e-09   4.010e-13
3   2Y4   LVC244A_OUT   4.200e-02   2.619e-09   3.020e-13
4   1A2   LVC244A_IN   4.500e-02   2.273e-09   2.020e-13
5   2Y3   LVC244A_OUT   4.500e-02   2.248e-09   2.240e-13
6   1A3   LVC244A_IN   4.500e-02   2.273e-09   2.260e-13
7   2Y2   LVC244A_OUT   4.400e-02   2.323e-09   2.050e-13
8   1A4   LVC244A_IN   4.600e-02   2.704e-09   3.070e-13
9   2Y1   LVC244A_OUT   6.000e-02   3.265e-09   4.110e-13
10   GND   GND   5.700e-02   3.506e-09   4.360e-13
11   2A1   LVC244A_IN   5.800e-02   3.553e-09   4.370e-13
12   1Y4   LVC244A_OUT   5.800e-02   3.193e-09   4.050e-13
13   2A2   LVC244A_IN   4.200e-02   2.704e-09   3.110e-13
14   1Y3   LVC244A_OUT   4.600e-02   2.392e-09   2.100e-13
15   2A3   LVC244A_IN   4.700e-02   2.334e-09   2.290e-13
16   1Y2   LVC244A_OUT   4.700e-02   2.300e-09   2.270e-13
17   2A4   LVC244A_IN   4.700e-02   2.349e-09   2.070e-13
18   1Y1   LVC244A_OUT   4.500e-02   2.677e-09   3.060e-13
19   2NOE   LVC244A_NOE   6.000e-02   3.235e-09   4.060e-13
20   VCC   POWER   5.600e-02   3.487e-09   4.430e-13
| Component SN74LVC244A_DGV 20-PIN TVSOP
[Component]   SN74LVC244A_DGV
[Manufacturer]   Texas Instruments, Inc.
[Package]
|   typ   min   max
R_pkg   4.400e-02   3.800e-02   4.800e-02
L_pkg   2.561e-09   2.236e-09   2.961e-09
C_pkg   3.420e-13   2.640e-13   4.460e-13
[Pin]   signal_name   model_name   R_pin   L_pin   C_pin
1   1NOE   LVC244A_NOE   4.400e-02   2.935e-09   4.170e-13
2   1A1   LVC244A_IN   4.200e-02   2.869e-09   4.460e-13
3   2Y4   LVC244A_OUT   4.300e-02   2.399e-09   3.160e-13
4   1A2   LVC244A_IN   4.400e-02   2.236e-09   2.650e-13
5   2Y3   LVC244A_OUT   4.600e-02   2.278e-09   2.640e-13
6   1A3   LVC244A_IN   4.500e-02   2.274e-09   2.640e-13
7   2Y2   LVC244A_OUT   4.400e-02   2.285e-09   2.690e-13
8   1A4   LVC244A_IN   4.300e-02   2.452e-09   3.200e-13
9   2Y1   LVC244A_OUT   4.400e-02   2.900e-09   4.460e-13
10   GND   GND   4.400e-02   2.961e-09   4.180e-13
11   2A1   LVC244A_IN   4.500e-02   2.954e-09   4.180e-13
12   1Y4   LVC244A_OUT   4.200e-02   2.847e-09   4.430e-13
13   2A2   LVC244A_IN   4.500e-02   2.453e-09   3.190e-13
14   1Y3   LVC244A_OUT   4.500e-02   2.297e-09   2.690e-13
15   2A3   LVC244A_IN   4.800e-02   2.334e-09   2.680e-13
16   1Y2   LVC244A_OUT   4.800e-02   2.335e-09   2.670e-13
17   2A4   LVC244A_IN   4.600e-02   2.299e-09   2.680e-13
18   1Y1   LVC244A_OUT   4.600e-02   2.457e-09   3.200e-13
19   2NOE   LVC244A_NOE   4.300e-02   2.848e-09   4.410e-13
20   VCC   POWER   3.800e-02   2.812e-09   4.080e-13
| Component SN74LVC244A_DW 20-PIN SOIC
[Component]   SN74LVC244A_DW
[Manufacturer]   Texas Instruments, Inc.
[Package]
|   typ   min   max
R_pkg   3.800e-02   3.300e-02   4.500e-02
L_pkg   5.012e-09   4.110e-09   6.349e-09
C_pkg   7.170e-13   5.300e-13   8.680e-13
[Pin]   signal_name   model_name   R_pin   L_pin   C_pin
1   1NOE   LVC244A_NOE   4.200e-02   6.336e-09   8.650e-13
2   1A1   LVC244A_IN   4.300e-02   5.542e-09   8.670e-13
3   2Y4   LVC244A_OUT   3.400e-02   4.714e-09   7.320e-13
4   1A2   LVC244A_IN   3.400e-02   4.377e-09   5.910e-13
5   2Y3   LVC244A_OUT   3.600e-02   4.130e-09   5.330e-13
6   1A3   LVC244A_IN   3.500e-02   4.111e-09   5.300e-13
7   2Y2   LVC244A_OUT   3.400e-02   4.284e-09   5.830e-13
8   1A4   LVC244A_IN   3.400e-02   4.634e-09   7.260e-13
9   2Y1   LVC244A_OUT   4.000e-02   5.518e-09   8.650e-13
10   GND   GND   4.300e-02   6.349e-09   8.660e-13
11   2A1   LVC244A_IN   4.100e-02   6.281e-09   8.610e-13
12   1Y4   LVC244A_OUT   4.500e-02   5.561e-09   8.680e-13
13   2A2   LVC244A_IN   3.300e-02   4.778e-09   7.420e-13
14   1Y3   LVC244A_OUT   3.500e-02   4.414e-09   5.960e-13
15   2A3   LVC244A_IN   3.500e-02   4.110e-09   5.330e-13
16   1Y2   LVC244A_OUT   3.600e-02   4.130e-09   5.330e-13
17   2A4   LVC244A_IN   3.400e-02   4.377e-09   5.910e-13
18   1Y1   LVC244A_OUT   3.400e-02   4.714e-09   7.310e-13
19   2NOE   LVC244A_NOE   4.300e-02   5.569e-09   8.680e-13
20   VCC   POWER   4.200e-02   6.308e-09   8.640e-13
| Component SN74LVC244A_DB 20-PIN SSOP
[Component]   SN74LVC244A_DB
[Manufacturer]   Texas Instruments, Inc.
[Package]
|   typ   min   max
R_pkg   4.000e-02   3.500e-02   5.100e-02
L_pkg   3.495e-09   3.035e-09   4.314e-09
C_pkg   4.200e-13   3.460e-13   5.020e-13
[Pin]   signal_name   model_name   R_pin   L_pin   C_pin
1   1NOE   LVC244A_NOE   4.900e-02   4.310e-09   5.020e-13
2   1A1   LVC244A_IN   4.800e-02   3.903e-09   4.870e-13
3   2Y4   LVC244A_OUT   3.500e-02   3.189e-09   3.960e-13
4   1A2   LVC244A_IN   3.500e-02   3.036e-09   3.470e-13
5   2Y3   LVC244A_OUT   3.500e-02   3.035e-09   3.670e-13
6   1A3   LVC244A_IN   3.500e-02   3.035e-09   3.670e-13
7   2Y2   LVC244A_OUT   3.500e-02   3.036e-09   3.470e-13
8   1A4   LVC244A_IN   3.500e-02   3.189e-09   3.970e-13
9   2Y1   LVC244A_OUT   4.700e-02   3.899e-09   4.880e-13
10   GND   GND   5.100e-02   4.314e-09   5.000e-13
11   2A1   LVC244A_IN   5.100e-02   4.314e-09   5.000e-13
12   1Y4   LVC244A_OUT   4.700e-02   3.899e-09   4.880e-13
13   2A2   LVC244A_IN   3.500e-02   3.189e-09   3.970e-13
14   1Y3   LVC244A_OUT   3.500e-02   3.036e-09   3.460e-13
15   2A3   LVC244A_IN   3.500e-02   3.035e-09   3.670e-13
16   1Y2   LVC244A_OUT   3.500e-02   3.035e-09   3.670e-13
17   2A4   LVC244A_IN   3.500e-02   3.036e-09   3.460e-13
18   1Y1   LVC244A_OUT   3.500e-02   3.189e-09   3.970e-13
19   2NOE   LVC244A_NOE   4.700e-02   3.899e-09   4.880e-13
20   VCC   POWER   5.100e-02   4.314e-09   5.020e-13
| Component SN74LVC244A_RGY 20-PIN QFN
[Component]   SN74LVC244A_RGY
[Manufacturer]   Texas Instruments, Inc.
[Package]
|   typ   min   max
R_pkg   5.000e-02   4.600e-02   5.500e-02
L_pkg   1.119e-09   1.025e-09   1.227e-09
C_pkg   3.520e-13   3.440e-13   3.630e-13
[Pin]   signal_name   model_name   R_pin   L_pin   C_pin
1   1NOE   LVC244A_NOE   5.200e-02   1.167e-09   3.600e-13
2   1A1   LVC244A_IN   4.700e-02   1.049e-09   3.440e-13
3   2Y4   LVC244A_OUT   4.700e-02   1.055e-09   3.450e-13
4   1A2   LVC244A_IN   5.000e-02   1.119e-09   3.500e-13
5   2Y3   LVC244A_OUT   5.500e-02   1.227e-09   3.600e-13
6   1A3   LVC244A_IN   5.200e-02   1.167e-09   3.550e-13
7   2Y2   LVC244A_OUT   4.900e-02   1.087e-09   3.480e-13
8   1A4   LVC244A_IN   4.700e-02   1.054e-09   3.460e-13
9   2Y1   LVC244A_OUT   4.900e-02   1.091e-09   3.490e-13
10   GND   GND   5.300e-02   1.184e-09   3.620e-13
11   2A1   LVC244A_IN   5.300e-02   1.181e-09   3.600e-13
12   1Y4   LVC244A_OUT   5.000e-02   1.108e-09   3.490e-13
13   2A2   LVC244A_IN   4.800e-02   1.075e-09   3.470e-13
14   1Y3   LVC244A_OUT   5.000e-02   1.107e-09   3.490e-13
15   2A3   LVC244A_IN   5.400e-02   1.200e-09   3.620e-13
16   1Y2   LVC244A_OUT   5.100e-02   1.141e-09   3.570e-13
17   2A4   LVC244A_IN   4.700e-02   1.043e-09   3.440e-13
18   1Y1   LVC244A_OUT   4.600e-02   1.025e-09   3.440e-13
19   2NOE   LVC244A_NOE   4.900e-02   1.090e-09   3.490e-13
20   VCC   POWER   5.400e-02   1.204e-09   3.630e-13
| Component SN74LVC244A_N 20-PIN PDIP
[Component]   SN74LVC244A_N
[Manufacturer]   Texas Instruments, Inc.
[Package]
|   typ   min   max
R_pkg   4.300e-02   3.800e-02   5.000e-02
L_pkg   7.384e-09   4.680e-09   1.032e-08
C_pkg   5.100e-13   2.310e-13   8.210e-13
[Pin]   signal_name   model_name   R_pin   L_pin   C_pin
1   1NOE   LVC244A_NOE   4.200e-02   9.427e-09   8.100e-13
2   1A1   LVC244A_IN   4.600e-02   8.544e-09   4.560e-13
3   2Y4   LVC244A_OUT   4.800e-02   7.163e-09   4.350e-13
4   1A2   LVC244A_IN   4.000e-02   4.825e-09   2.610e-13
5   2Y3   LVC244A_OUT   4.000e-02   5.284e-09   6.480e-13
6   1A3   LVC244A_IN   4.000e-02   4.686e-09   2.320e-13
7   2Y2   LVC244A_OUT   4.000e-02   6.359e-09   4.890e-13
8   1A4   LVC244A_IN   3.800e-02   7.982e-09   4.750e-13
9   2Y1   LVC244A_OUT   4.300e-02   9.403e-09   4.750e-13
10   GND   GND   5.000e-02   1.032e-08   8.050e-13
11   2A1   LVC244A_IN   5.000e-02   1.028e-08   8.100e-13
12   1Y4   LVC244A_OUT   4.300e-02   9.383e-09   4.770e-13
13   2A2   LVC244A_IN   3.800e-02   7.978e-09   4.760e-13
14   1Y3   LVC244A_OUT   4.000e-02   6.302e-09   4.920e-13
15   2A3   LVC244A_IN   4.000e-02   4.680e-09   2.310e-13
16   1Y2   LVC244A_OUT   4.000e-02   5.284e-09   6.480e-13
17   2A4   LVC244A_IN   4.000e-02   4.822e-09   2.610e-13
18   1Y1   LVC244A_OUT   4.700e-02   7.118e-09   4.390e-13
19   2NOE   LVC244A_NOE   4.600e-02   8.492e-09   4.610e-13
20   VCC   POWER   4.300e-02   9.348e-09   8.210e-13
| Component SN74LVC244A_NS 20-PIN SOP
[Component]   SN74LVC244A_NS
[Manufacturer]   Texas Instruments, Inc.
[Package]
|   typ   min   max
R_pkg   4.400e-02   2.900e-02   5.800e-02
L_pkg   3.666e-09   2.317e-09   5.115e-09
C_pkg   5.480e-13   3.160e-13   7.250e-13
[Pin]   signal_name   model_name   R_pin   L_pin   C_pin
1   1NOE   LVC244A_NOE   5.800e-02   5.115e-09   7.250e-13
2   1A1   LVC244A_IN   5.300e-02   4.591e-09   7.240e-13
3   2Y4   LVC244A_OUT   4.900e-02   3.754e-09   5.720e-13
4   1A2   LVC244A_IN   2.900e-02   2.549e-09   3.880e-13
5   2Y3   LVC244A_OUT   3.100e-02   2.317e-09   3.160e-13
6   1A3   LVC244A_IN   3.100e-02   2.317e-09   3.160e-13
7   2Y2   LVC244A_OUT   2.900e-02   2.556e-09   3.990e-13
8   1A4   LVC244A_IN   4.900e-02   3.754e-09   5.790e-13
9   2Y1   LVC244A_OUT   5.300e-02   4.591e-09   7.240e-13
10   GND   GND   5.800e-02   5.115e-09   7.250e-13
11   2A1   LVC244A_IN   5.800e-02   5.115e-09   7.250e-13
12   1Y4   LVC244A_OUT   5.300e-02   4.591e-09   7.240e-13
13   2A2   LVC244A_IN   4.900e-02   3.754e-09   5.790e-13
14   1Y3   LVC244A_OUT   2.900e-02   2.557e-09   3.990e-13
15   2A3   LVC244A_IN   3.100e-02   2.317e-09   3.160e-13
16   1Y2   LVC244A_OUT   3.100e-02   2.317e-09   3.160e-13
17   2A4   LVC244A_IN   2.900e-02   2.557e-09   3.990e-13
18   1Y1   LVC244A_OUT   4.900e-02   3.754e-09   5.790e-13
19   2NOE   LVC244A_NOE   5.300e-02   4.591e-09   7.240e-13
20   VCC   POWER   5.800e-02   5.115e-09   7.250e-13
| Component SN74LVC244A_GQN 20-PIN JRBGA
[Component]   SN74LVC244A_GQN
[Manufacturer]   Texas Instruments, Inc.
[Package]
|   typ   min   max
R_pkg   4.300e-02   3.300e-02   6.100e-02
L_pkg   1.317e-09   8.960e-10   2.088e-09
C_pkg   1.130e-13   6.400e-14   1.900e-13
[Pin]   signal_name   model_name   R_pin   L_pin   C_pin
A2   1NOE   LVC244A_NOE   3.800e-02   1.199e-09   1.210e-13
A1   1A1   LVC244A_IN   4.000e-02   1.067e-09   1.020e-13
B3   2Y4   LVC244A_OUT   6.100e-02   1.999e-09   1.900e-13
B1   1A2   LVC244A_IN   3.300e-02   9.630e-10   7.100e-14
C2   2Y3   LVC244A_OUT   4.900e-02   1.523e-09   1.230e-13
C1   1A3   LVC244A_IN   3.300e-02   8.960e-10   6.400e-14
D3   2Y2   LVC244A_OUT   6.100e-02   1.899e-09   1.640e-13
D1   1A4   LVC244A_IN   3.300e-02   8.980e-10   6.700e-14
E2   2Y1   LVC244A_OUT   4.900e-02   1.514e-09   1.280e-13
E1   GND   GND   3.600e-02   1.006e-09   9.400e-14
E3   2A1   LVC244A_IN   4.900e-02   1.683e-09   1.460e-13
E4   1Y4   LVC244A_OUT   3.300e-02   1.121e-09   8.900e-14
D2   2A2   LVC244A_IN   6.100e-02   2.088e-09   1.730e-13
D4   1Y3   LVC244A_OUT   3.300e-02   1.027e-09   7.100e-14
C3   2A3   LVC244A_IN   4.900e-02   1.558e-09   1.240e-13
C4   1Y2   LVC244A_OUT   3.300e-02   9.280e-10   6.700e-14
B2   2A4   LVC244A_IN   6.100e-02   1.921e-09   1.770e-13
B4   1Y1   LVC244A_OUT   3.300e-02   9.010e-10   7.700e-14
A4   2NOE   LVC244A_NOE   3.700e-02   9.900e-10   9.800e-14
A3   VCC   POWER   3.500e-02   1.168e-09   1.190e-13
| Component SN74LVC244A_ZQN 20-PIN JRBGA
[Component]   SN74LVC244A_ZQN
[Manufacturer]   Texas Instruments, Inc.
[Package]
|   typ   min   max
R_pkg   4.300e-02   3.300e-02   6.100e-02
L_pkg   1.317e-09   8.960e-10   2.088e-09
C_pkg   1.130e-13   6.400e-14   1.900e-13
[Pin]   signal_name   model_name   R_pin   L_pin   C_pin
A2   1NOE   LVC244A_NOE   3.800e-02   1.199e-09   1.210e-13
A1   1A1   LVC244A_IN   4.000e-02   1.067e-09   1.020e-13
B3   2Y4   LVC244A_OUT   6.100e-02   1.999e-09   1.900e-13
B1   1A2   LVC244A_IN   3.300e-02   9.630e-10   7.100e-14
C2   2Y3   LVC244A_OUT   4.900e-02   1.523e-09   1.230e-13
C1   1A3   LVC244A_IN   3.300e-02   8.960e-10   6.400e-14
D3   2Y2   LVC244A_OUT   6.100e-02   1.899e-09   1.640e-13
D1   1A4   LVC244A_IN   3.300e-02   8.980e-10   6.700e-14
E2   2Y1   LVC244A_OUT   4.900e-02   1.514e-09   1.280e-13
E1   GND   GND   3.600e-02   1.006e-09   9.400e-14
E3   2A1   LVC244A_IN   4.900e-02   1.683e-09   1.460e-13
E4   1Y4   LVC244A_OUT   3.300e-02   1.121e-09   8.900e-14
D2   2A2   LVC244A_IN   6.100e-02   2.088e-09   1.730e-13
D4   1Y3   LVC244A_OUT   3.300e-02   1.027e-09   7.100e-14
C3   2A3   LVC244A_IN   4.900e-02   1.558e-09   1.240e-13
C4   1Y2   LVC244A_OUT   3.300e-02   9.280e-10   6.700e-14
B2   2A4   LVC244A_IN   6.100e-02   1.921e-09   1.770e-13
B4   1Y1   LVC244A_OUT   3.300e-02   9.010e-10   7.700e-14
A4   2NOE   LVC244A_NOE   3.700e-02   9.900e-10   9.800e-14
A3   VCC   POWER   3.500e-02   1.168e-09   1.190e-13
| Model LVC244A_IN
[Model Selector]   LVC244A_IN
LVC244A_IN_18   1.8 volt Vcc
LVC244A_IN_25   2.5 volt Vcc
LVC244A_IN_33   3.3 volt Vcc
| Model LVC244A_NOE
[Model Selector]   LVC244A_NOE
LVC244A_NOE_18   1.8 volt Vcc
LVC244A_NOE_25   2.5 volt Vcc
LVC244A_NOE_33   3.3 volt Vcc
| Model LVC244A_OUT
[Model Selector]   LVC244A_OUT
LVC244A_OUT_18   1.8 volt Vcc
LVC244A_OUT_25   2.5 volt Vcc
LVC244A_OUT_33   3.3 volt Vcc
| Models and submodels in the file (9): LVC244A_IN_18 (Input), LVC244A_IN_25 (Input), LVC244A_IN_33 (Input), LVC244A_NOE_18 (Input), LVC244A_NOE_25 (Input), LVC244A_NOE_33 (Input), LVC244A_OUT_18 (3-state), LVC244A_OUT_25 (3-state), LVC244A_OUT_33 (3-state)

| m59a.ibs * IBIS 4.0 Model
| Die rev "D"
| 2Gb Nand Flash Ibis model
| This Model is applicable for Commercial Temp Range (0c <= Ta <= 70C)
| Part Number   VCC   Architecture   Package
|MT29F2G08AADWP   3.3V   2Gig x  8   48-PIN TSOP CPL
|MT29F2G16AADWP   3.3V   2Gig x  16   48-PIN TSOP CPL
|MT29F2G08ABDWP   1.8V   2Gig x  8   48-PIN TSOP CPL
|MT29F2G16ABDWP   1.8V   2Gig x  16   48-PIN TSOP CPL
|MT29F2G08ABDHC   1.8V   2Gig x  8   63-Ball VFBGA
|MT29F2G16ABDHC   1.8V   2Gig x  16   63-Ball VFBGA
|MT29F2G08AADM59A   3.3V   2Gig x  8   Bare Die
|MT29F2G16AADM59A   3.3V   2Gig x  16   Bare Die
|MT29F2G08ABDM59A   1.8V   2Gig x  8   Bare Die
|MT29F2G16ABDM59A   1.8V   2Gig x  16   Bare Die
[IBIS Ver]   4.0
[Comment char]  |_char
[File name]   m59a.ibs
[Date]   01/12/2009
[File Rev]   2.6
[Source]   From silicon level SPICE model at Micron Technology, Inc.
   For support, email modelsupport@micron.com.
[Notes]   Rev 2.0: 07/25/2007
   - First Revision Model data (1.8V Data) created for j40d ibis model
   - No Power Clamp diode in RDBY_* and INPUT_* models
   - C_comp matched to silicon
   Rev 2.1: 10/11/2007
   - Re-generated IBIS data using latest process model
   - IQ SUMMARY:Overall Quality of component and models Level 2b
   See Micron IBIS Model Quality Report for full IQ SUMMARY
   - C_comp matched to silicon
   Rev 2.2: 03/24/2008
   - Corrected TSOP component names
   Rev 2.3: 06/04/2008
   - Added bare die components for 1.8V VCC
   - Corrected bare die pinmap and component names for 3.3V VCC
   Rev 2.4: 08/06/2008
   - Added package components for 1.8V TSOP x8
   Rev 2.5: 09/03/2008
   - Removed package components for 1.8V TSOP x8 as not offered
   in production version
   Rev 2.6: 01/12/2009
   - Added package components for 1.8V TSOP x8 and TSOP x16 based on
   latest production information
[Disclaimer]  This software code and all associated documentation, comments
              or other information (collectively "Software") is provided
              "AS IS" without warranty of any kind. MICRON TECHNOLOGY, INC.
              ("MTI") EXPRESSLY DISCLAIMS ALL WARRANTIES EXPRESS OR IMPLIED,
              INCLUDING BUT NOT LIMITED TO, NONINFRINGEMENT OF THIRD PARTY
              RIGHTS, AND ANY IMPLIED WARRANTIES OF MERCHANTABILITY OR
              FITNESS FOR ANY PARTICULAR PURPOSE. MTI DOES NOT WARRANT THAT
              THE SOFTWARE WILL MEET YOUR REQUIREMENTS, OR THAT THE
              OPERATION OF THE SOFTWARE WILL BE UNINTERRUPTED OR ERROR-FREE.
              FURTHERMORE, MTI DOES NOT MAKE ANY REPRESENTATIONS REGARDING
              THE USE OR THE RESULTS OF THE USE OF THE SOFTWARE IN TERMS OF
              ITS CORRECTNESS, ACCURACY, RELIABILITY, OR OTHERWISE. THE
              ENTIRE RISK ARISING OUT OF USE OR PERFORMANCE OF THE SOFTWARE
              REMAINS WITH YOU. IN NO EVENT SHALL MTI, ITS AFFILIATED
              COMPANIES OR THEIR SUPPLIERS BE LIABLE FOR ANY DIRECT,
              INDIRECT, CONSEQUENTIAL, INCIDENTAL, OR SPECIAL DAMAGES
              (INCLUDING, WITHOUT LIMITATION, DAMAGES FOR LOSS OF PROFITS,
              BUSINESS INTERRUPTION, OR LOSS OF INFORMATION) ARISING OUT OF
              YOUR USE OF OR INABILITY TO USE THE SOFTWARE, EVEN IF MTI HAS
              BEEN ADVISED OF THE POSSIBILITY OF SUCH DAMAGES. Because some
              jurisdictions prohibit the exclusion or limitation of
              liability for consequential or incidental damages, the above
              limitation may not apply to you.
[Copyright]   Copyright 2005 Micron Technology, Inc. All rights reserved.
|   COMPONENT: MT29F2G08AADWP (TSOP x8,VCC=3.3V )
[Component]   MT29F2G08AADWP
[Manufacturer]  Micron Technology,Inc.
[Package]
|   typ   min   max
R_pkg   431.21m   426.74m   435.41m
L_pkg   5.27nH   5.13nH   5.42nH
C_pkg   0.68pF   0.61pF   0.74pF
[Pin]   signal_name model_name   R_pin   L_pin   C_pin
1   NC   NC
2   NC   NC
3   NC   NC
4   NC   NC
5   NC   NC
6   NC   NC
7   RB#   RDBY_OD_33   429.34m   5.36nH   0.68pF
8   RE#   INPUT_33   429.44m   5.29nH   0.67pF
9   CE#   INPUT_33   428.92m   5.25nH   0.66pF
10   NC   NC
11   NC   NC
12   VCC   POWER   162.36m   3.24nH   0.73pF
13   VSS   GND   297.85m   8.68nH   NA
14   NC   NC
15   NC   NC
16   CLE   INPUT_33   426.74m   5.13nH   0.61pF
17   ALE   INPUT_33   428.50m   5.18nH   0.63pF
18   WE#   INPUT_33   429.45m   5.23nH   0.65pF
19   WP#   INPUT_33   430.37m   5.28nH   0.66pF
20   NC   NC
21   NC   NC
22   NC   NC
23   NC   NC
24   NC   NC
25   VSS   GND   438.53m   6.22nH   NA
26   NC   NC
27   NC   NC
28   NC   NC
29   IO0   DQ_33   430.43m   5.30nH   0.73pF
30   IO1   DQ_33   430.15m   5.24nH   0.71pF
31   IO2   DQ_33   434.90m   5.23nH   0.72pF
32   IO3   DQ_33   434.01m   5.19nH   0.70pF
33   NC   NC
34   NC   NC
35   NC   NC
36   VSS   GND   438.53m   6.22nH   NA
37   VCC   POWER   231.40m   3.72nH   0.66pF
38   DNU   NC
39   VCC   POWER   231.40m   3.72nH   0.66pF
40   NC   NC
41   IO4   DQ_33   434.21m   5.26nH   0.69pF
42   IO5   DQ_33   435.41m   5.31nH   0.70pF
43   IO6   DQ_33   432.76m   5.34nH   0.71pF
44   IO7   DQ_33   433.58m   5.42nH   0.74pF
45   NC   NC
46   NC   NC
47   DNU   NC
48   VSS   GND   438.53m   6.22nH   NA
|   COMPONENT: MT29F2G08ABDWP (TSOP x8,VCC=1.8V )
[Component]   MT29F2G08ABDWP
[Manufacturer]  Micron Technology,Inc.
[Package]
|   typ   min   max
R_pkg   431.21m   426.74m   435.41m
L_pkg   5.27nH   5.13nH   5.42nH
C_pkg   0.68pF   0.61pF   0.74pF
[Pin]   signal_name model_name   R_pin   L_pin   C_pin
1   NC   NC
2   NC   NC
3   NC   NC
4   NC   NC
5   NC   NC
6   NC   NC
7   RB#   RDBY_OD_18   429.34m   5.36nH   0.68pF
8   RE#   INPUT_18   429.44m   5.29nH   0.67pF
9   CE#   INPUT_18   428.92m   5.25nH   0.66pF
10   NC   NC
11   NC   NC
12   VCC   POWER   162.36m   3.24nH   0.73pF
13   VSS   GND   297.85m   8.68nH   NA
14   NC   NC
15   NC   NC
16   CLE   INPUT_18   426.74m   5.13nH   0.61pF
17   ALE   INPUT_18   428.50m   5.18nH   0.63pF
18   WE#   INPUT_18   429.45m   5.23nH   0.65pF
19   WP#   INPUT_18   430.37m   5.28nH   0.66pF
20   NC   NC
21   NC   NC
22   NC   NC
23   NC   NC
24   NC   NC
25   VSS   GND   438.53m   6.22nH   NA
26   NC   NC
27   NC   NC
28   NC   NC
29   IO0   DQ_18   430.43m   5.30nH   0.73pF
30   IO1   DQ_18   430.15m   5.24nH   0.71pF
31   IO2   DQ_18   434.90m   5.23nH   0.72pF
32   IO3   DQ_18   434.01m   5.19nH   0.70pF
33   NC   NC
34   NC   NC
35   NC   NC
36   VSS   GND   438.53m   6.22nH   NA
37   VCC   POWER   231.40m   3.72nH   0.66pF
38   DNU   NC
39   VCC   POWER   231.40m   3.72nH   0.66pF
40   NC   NC
41   IO4   DQ_18   434.21m   5.26nH   0.69pF
42   IO5   DQ_18   435.41m   5.31nH   0.70pF
43   IO6   DQ_18   432.76m   5.34nH   0.71pF
44   IO7   DQ_18   433.58m   5.42nH   0.74pF
45   NC   NC
46   NC   NC
47   DNU   NC
48   VSS   GND   438.53m   6.22nH   NA
|   COMPONENT: MT29F2G16AADWP (TSOP x16,VCC=3.3V )
[Component]   MT29F2G16AADWP
[Manufacturer]  Micron Technology,Inc.
[Package]
|   typ   min   max
R_pkg   434.17m   426.74m   444.17m
L_pkg   5.40nH   5.13nH   6.09nH
C_pkg   0.72pF   0.61pF   0.87pF
[Pin]   signal_name model_name   R_pin   L_pin   C_pin
1   NC   NC
2   NC   NC
3   NC   NC
4   NC   NC
5   NC   NC
6   NC   NC
7   RB#   RDBY_OD_33   429.34m   5.36nH   0.68pF
8   RE#   INPUT_33   429.44m   5.29nH   0.67pF
9   CE#   INPUT_33   428.92m   5.25nH   0.66pF
10   NC   NC
11   NC   NC
12   VCC   POWER   162.36m   3.24nH   0.73pF
13   VSS   GND   297.85m   8.68nH   NA
14   NC   NC
15   NC   NC
16   CLE   INPUT_33   426.74m   5.13nH   0.61pF
17   ALE   INPUT_33   428.50m   5.18nH   0.63pF
18   WE#   INPUT_33   429.45m   5.23nH   0.65pF
19   WP#   INPUT_33   430.37m   5.28nH   0.66pF
20   NC   NC
21   NC   NC
22   NC   NC
23   NC   NC
24   NC   NC
25   VSS   GND   297.85m   8.68nH   NA
26   IO8   DQ_33   443.64m   5.96nH   0.87pF
27   IO9   DQ_33   442.15m   5.74nH   0.83pF
28   IO10   DQ_33   439.09m   5.54nH   0.78pF
29   IO0   DQ_33   430.43m   5.30nH   0.73pF
30   IO1   DQ_33   430.15m   5.24nH   0.71pF
31   IO2   DQ_33   434.90m   5.23nH   0.72pF
32   IO3   DQ_33   434.01m   5.19nH   0.70pF
33   IO11   DQ_33   432.29m   5.13nH   0.68pF
34   VCC   POWER   429.15m   5.08nH   0.64pF
35   NC   NC
36   VSS   GND   438.53m   6.22nH   NA
37   VCC   POWER   231.40m   3.72nH   0.66pF
38   DNU   NC
39   VCC   POWER   431.28m   5.15nH   0.65pF
40   IO12   DQ_33   432.50m   5.21nH   0.67pF
41   IO4   DQ_33   434.21m   5.26nH   0.69pF
42   IO5   DQ_33   435.41m   5.31nH   0.70pF
43   IO6   DQ_33   432.76m   5.34nH   0.71pF
44   IO7   DQ_33   433.58m   5.42nH   0.74pF
45   IO13   DQ_33   440.58m   5.64nH   0.78pF
46   IO14   DQ_33   443.26m   5.86nH   0.83pF
47   IO15   DQ_33   444.17m   6.09nH   0.86pF
48   VSS   GND   440.53m   6.37nH   NA
|   COMPONENT: MT29F2G16ABDWP  (TSOP x16,VCC=1.8V )
[Component]   MT29F2G16ABDWP
[Manufacturer]  Micron Technology,Inc.
[Package]
|   typ   min   max
R_pkg   434.17m   426.74m   444.17m
L_pkg   5.40nH   5.13nH   6.09nH
C_pkg   0.72pF   0.61pF   0.87pF
[Pin]   signal_name model_name   R_pin   L_pin   C_pin
1   NC   NC
2   NC   NC
3   NC   NC
4   NC   NC
5   NC   NC
6   NC   NC
7   RB#   RDBY_OD_18   429.34m   5.36nH   0.68pF
8   RE#   INPUT_18   429.44m   5.29nH   0.67pF
9   CE#   INPUT_18   428.92m   5.25nH   0.66pF
10   NC   NC
11   NC   NC
12   VCC   POWER   162.36m   3.24nH   0.73pF
13   VSS   GND   297.85m   8.68nH   NA
14   NC   NC
15   NC   NC
16   CLE   INPUT_18   426.74m   5.13nH   0.61pF
17   ALE   INPUT_18   428.50m   5.18nH   0.63pF
18   WE#   INPUT_18   429.45m   5.23nH   0.65pF
19   WP#   INPUT_18   430.37m   5.28nH   0.66pF
20   NC   NC
21   NC   NC
22   NC   NC
23   NC   NC
24   NC   NC
25   VSS   GND   297.85m   8.68nH   NA
26   IO8   DQ_18   443.64m   5.96nH   0.87pF
27   IO9   DQ_18   442.15m   5.74nH   0.83pF
28   IO10   DQ_18   439.09m   5.54nH   0.78pF
29   IO0   DQ_18   430.43m   5.30nH   0.73pF
30   IO1   DQ_18   430.15m   5.24nH   0.71pF
31   IO2   DQ_18   434.90m   5.23nH   0.72pF
32   IO3   DQ_18   434.01m   5.19nH   0.70pF
33   IO11   DQ_18   432.29m   5.13nH   0.68pF
34   VCC   POWER   429.15m   5.08nH   0.64pF
35   NC   NC
36   VSS   GND   438.53m   6.22nH   NA
37   VCC   POWER   231.40m   3.72nH   0.66pF
38   DNU   NC
39   VCC   POWER   431.28m   5.15nH   0.65pF
40   IO12   DQ_18   432.50m   5.21nH   0.67pF
41   IO4   DQ_18   434.21m   5.26nH   0.69pF
42   IO5   DQ_18   435.41m   5.31nH   0.70pF
43   IO6   DQ_18   432.76m   5.34nH   0.71pF
44   IO7   DQ_18   433.58m   5.42nH   0.74pF
45   IO13   DQ_18   440.58m   5.64nH   0.78pF
46   IO14   DQ_18   443.26m   5.86nH   0.83pF
47   IO15   DQ_18   444.17m   6.09nH   0.86pF
48   VSS   GND   440.53m   6.37nH   NA
|   COMPONENT: MT29F2G08ABDHC (63-Ball VFBGA x8,VCC=1.8V )
[Component]   MT29F2G08ABDHC
[Manufacturer]  Micron Technology,Inc.
[Package]
|   typ   min   max
R_pkg   123.67m   101.67m   161.90m
L_pkg   2.85nH   2.14nH   4.07nH
C_pkg   0.69pF   0.57pF   0.88pF
[Pin]   signal_name model_name   R_pin   L_pin   C_pin
A1   NC   NC
A2   NC   NC
A9   NC   NC
A10   NC   NC
B1   NC   NC
B9   NC   NC
B10   NC   NC
C3   WP#   INPUT_18   101.67m   2.14nH   0.60pF
C4   ALE   INPUT_18   103.99m   2.18nH   0.62pF
C5   VSS   GND   114.71m   4.81nH   NA
C6   CE#   INPUT_18   105.79m   2.22nH   0.61pF
C7   WE#   INPUT_18   133.81m   3.05nH   0.77pF
C8   RB#   RDBY_OD_33   103.97m   2.14nH   0.59pF
D3   VCC   POWER   164.04m   6.90nH   1.88pF
D4   RE#   INPUT_18   161.90m   4.07nH   0.88pF
D5   CLE   INPUT_18   130.44m   2.85nH   0.74pF
D6   NC   NC
D7   NC   NC
D8   NC   NC
E3   NC   NC
E4   NC   NC
E5   NC   NC
E6   NC   NC
E7   NC   NC
E8   NC   NC
F3   NC   NC
F4   NC   NC
F5   NC   NC
F6   NC   NC
F7   VSS   GND   114.71m   4.81nH   NA
F8   NC   NC
G3   DNU   NC
G4   VCC   POWER   164.04m   6.90nH   1.88pF
G5   LOCK   INPUT_18   158.00m   3.92nH   0.88pF
G6   NC   NC
G7   NC   NC
G8   NC   NC   226.62m   6.81nH   1.19pF
H3   NC   NC
H4   IO0   DQ_18   146.85m   3.74nH   0.82pF
H5   NC   NC
H6   NC   NC
H7   NC   NC
H8   VCC   POWER   164.04m   6.90nH   1.88pF
J3   NC   NC
J4   IO1   DQ_18   129.39m   3.12nH   0.73pF
J5   NC   NC
J6   VCC   POWER   164.04m   6.90nH   1.88pF
J7   IO5   DQ_18   121.73m   2.90nH   0.64pF
J8   IO7   DQ_18   125.60m   3.00nH   0.69pF
K3   VSS   GND   114.71m   4.81nH   NA
K4   IO2   DQ_18   111.78m   2.57nH   0.62pF
K5   IO3   DQ_18   128.66m   3.01nH   0.70pF
K6   IO4   DQ_18   107.15m   2.38nH   0.59pF
K7   IO6   DQ_18   108.04m   2.37nH   0.57pF
K8   VSS   GND   114.71m   4.81nH   NA
L1   NC   NC
L2   NC   NC
L9   NC   NC
L10   NC   NC
M1   NC   NC
M2   NC   NC
M9   NC   NC
M10   NC   NC
|   COMPONENT: MT29F2G16ABDHC (63-Ball VFBGA x16,VCC=1.8V )
[Component]   MT29F2G16ABDHC
[Manufacturer]  Micron Technology,Inc.
[Package Model] M59A_VFBGA_FULL_PKG
[Package]
|   typ   min   max
R_pkg   133.40m   101.67m   172.37m
L_pkg   3.19nH   2.14nH   4.53nH
C_pkg   0.75pF   0.57pF   1.04pF
[Pin]   signal_name model_name   R_pin   L_pin   C_pin
A1   NC   NC
A2   NC   NC
A9   NC   NC
A10   NC   NC
B1   NC   NC
B9   NC   NC
B10   NC   NC
C3   WP#   INPUT_18   101.67m   2.14nH   0.60pF
C4   ALE   INPUT_18   103.99m   2.18nH   0.62pF
C5   VSS   GND   114.71m   4.81nH   NA
C6   CE#   INPUT_18   105.79m   2.22nH   0.61pF
C7   WE#   INPUT_18   133.81m   3.05nH   0.77pF
C8   RB#   RDBY_OD_33   103.97m   2.14nH   0.59pF
D3   VCC   POWER   164.04m   6.90nH   1.88pF
D4   RE#   INPUT_18   161.90m   4.07nH   0.88pF
D5   CLE   INPUT_18   130.44m   2.85nH   0.74pF
D6   NC   NC
D7   NC   NC
D8   NC   NC
E3   NC   NC
E4   NC   NC
E5   NC   NC
E6   NC   NC
E7   NC   NC
E8   NC   NC
F3   NC   NC
F4   NC   NC
F5   NC   NC
F6   NC   NC
F7   VSS   GND   114.71m   4.81nH   NA
F8   NC   NC
G3   DNU   NC
G4   VCC   POWER   164.04m   6.90nH   1.88pF
G5   LOCK   INPUT_18   158.00m   3.92nH   0.88pF
G6   IO13   DQ_18   166.71m   4.44nH   0.93pF
G7   IO15   DQ_18   164.86m   4.04nH   0.92pF
G8   NC   NC   226.62m   6.81nH   1.19pF
H3   IO8   DQ_18   154.75m   4.04nH   1.04pF
H4   IO0   DQ_18   146.85m   3.74nH   0.82pF
H5   IO10   DQ_18   172.37m   4.53nH   0.98pF
H6   IO12   DQ_18   137.61m   3.44nH   0.75pF
H7   IO14   DQ_18   145.76m   3.61nH   0.83pF
H8   VCC   POWER   164.04m   6.90nH   1.88pF
J3   IO9   DQ_18   134.01m   3.31nH   0.81pF
J4   IO1   DQ_18   129.39m   3.12nH   0.73pF
J5   IO11   DQ_18   146.75m   3.57nH   0.78pF
J6   VCC   POWER   164.04m   6.90nH   1.88pF
J7   IO5   DQ_18   121.73m   2.90nH   0.64pF
J8   IO7   DQ_18   125.60m   3.00nH   0.69pF
K3   VSS   GND   114.71m   4.81nH   NA
K4   IO2   DQ_18   111.78m   2.57nH   0.62pF
K5   IO3   DQ_18   128.66m   3.01nH   0.70pF
K6   IO4   DQ_18   107.15m   2.38nH   0.59pF
K7   IO6   DQ_18   108.04m   2.37nH   0.57pF
K8   VSS   GND   114.71m   4.81nH   NA
L1   NC   NC
L2   NC   NC
L9   NC   NC
L10   NC   NC
M1   NC   NC
M2   NC   NC
M9   NC   NC
M10   NC   NC
|   COMPONENT: MT29F2G08AADM59A (Bare Die x8,VCC=3.3V )
[Component]   MT29F2G08AADM59A
[Manufacturer]  Micron Technology,Inc.
[Package]
| variable   typ   min   max
R_pkg   0.001m   0.001m   0.001m
L_pkg   0.001nH   0.001nH   0.001nH
C_pkg   0.001pf   0.001pf   0.001pf
[Pin]   signal_name   model_name   R_pin   L_pin   C_pin
1   VSS   GND
2   DNU   NC
3   NC   NC
4   DNU   NC
5   NC   NC
6   DNU   NC
7   NC   NC
8   WP#   INPUT_33
9   IO0   DQ_33
10   WE#   INPUT_33
11   IO1   DQ_33
12   ALE   INPUT_33
13   IO2   DQ_33
14   CLE   INPUT_33
15   IO3   DQ_33
16   VSS   GND
17   NC   NC
18   VSS   GND
19   VCC   POWER
20   DNU   NC
21   VSS   GND
22   DNU   NC
23   VSS   GND
24   VSS   GND
25   VCC   POWER
26   VCC   POWER
27   DNU   NC
28   DNU   NC
29   VCC   POWER
30   VCC   POWER
31   VCC   POWER
32   DNU   NC
33   LOCK   INPUT_33
34   VCC   POWER
35   CE#   INPUT_33
36   NC   NC
37   RE#   INPUT_33
38   IO4   DQ_33
39   VCC   POWER
40   IO5   DQ_33
41   IO6   DQ_33
42   IO7   DQ_33
43   VCC   POWER
44   NC   NC
45   VSS   GND
46   NC   NC
47   VSS   GND
48   NC   NC
49   RB#   RDBY_OD_33
50   VCC   POWER
51   VSS   GND
52   VSS   GND
|   COMPONENT: MT29F2G16AADM59A (Bare Die x16,VCC=3.3V )
[Component]   MT29F2G16AADM59A
[Manufacturer]  Micron Technology,Inc.
[Package]
| variable   typ   min   max
R_pkg   0.001m   0.001m   0.001m
L_pkg   0.001nH   0.001nH   0.001nH
C_pkg   0.001pf   0.001pf   0.001pf
[Pin]   signal_name   model_name   R_pin   L_pin   C_pin
1   VSS   GND
2   DNU   NC
3   IO8   DQ_33
4   DNU   NC
5   IO9   DQ_33
6   DNU   NC
7   IO10   DQ_33
8   WP#   INPUT_33
9   IO0   DQ_33
10   WE#   INPUT_33
11   IO1   DQ_33
12   ALE   INPUT_33
13   IO2   DQ_33
14   CLE   INPUT_33
15   IO3   DQ_33
16   VSS   GND
17   IO11   DQ_33
18   VSS   GND
19   VCC   POWER
20   DNU   NC
21   VSS   GND
22   DNU   NC
23   VSS   GND
24   VSS   GND
25   VCC   POWER
26   VCC   POWER
27   DNU   NC
28   DNU   NC
29   VCC   POWER
30   VCC   POWER
31   VCC   POWER
32   DNU   NC
33   LOCK   INPUT_33
34   VCC   POWER
35   CE#   INPUT_33
36   IO12   DQ_33
37   RE#   INPUT_33
38   IO4   DQ_33
39   VCC   POWER
40   IO5   DQ_33
41   IO6   DQ_33
42   IO7   DQ_33
43   VCC   POWER
44   IO13   DQ_33
45   VSS   GND
46   IO14   DQ_33
47   VSS   GND
48   IO15   DQ_33
49   RB#   RDBY_OD_33
50   VCC   POWER
51   VSS   GND
52   VSS   GND
|   COMPONENT: MT29F2G08ABDM59A (Bare Die x8,VCC=1.8V )
[Component]   MT29F2G08ABDM59A
[Manufacturer]  Micron Technology,Inc.
[Package]
| variable   typ   min   max
R_pkg   0.001m   0.001m   0.001m
L_pkg   0.001nH   0.001nH   0.001nH
C_pkg   0.001pf   0.001pf   0.001pf
[Pin]   signal_name   model_name   R_pin   L_pin   C_pin
1   VSS   GND
2   DNU   NC
3   NC   NC
4   DNU   NC
5   NC   NC
6   DNU   NC
7   NC   NC
8   WP#   INPUT_18
9   IO0   DQ_18
10   WE#   INPUT_18
11   IO1   DQ_18
12   ALE   INPUT_18
13   IO2   DQ_18
14   CLE   INPUT_18
15   IO3   DQ_18
16   VSS   GND
17   NC   NC
18   VSS   GND
19   VCC   POWER
20   DNU   NC
21   VSS   GND
22   DNU   NC
23   VSS   GND
24   VSS   GND
25   VCC   POWER
26   VCC   POWER
27   DNU   NC
28   DNU   NC
29   VCC   POWER
30   VCC   POWER
31   VCC   POWER
32   DNU   NC
33   LOCK   INPUT_18
34   VCC   POWER
35   CE#   INPUT_18
36   NC   NC
37   RE#   INPUT_18
38   IO4   DQ_18
39   VCC   POWER
40   IO5   DQ_18
41   IO6   DQ_18
42   IO7   DQ_18
43   VCC   POWER
44   NC   NC
45   VSS   GND
46   NC   NC
47   VSS   GND
48   NC   NC
49   RB#   RDBY_OD_18
50   VCC   POWER
51   VSS   GND
52   VSS   GND
|   COMPONENT: MT29F2G16ABDM59A (Bare Die x16,VCC=1.8V )
[Component]   MT29F2G16ABDM59A
[Manufacturer]  Micron Technology,Inc.
[Package]
| variable   typ   min   max
R_pkg   0.001m   0.001m   0.001m
L_pkg   0.001nH   0.001nH   0.001nH
C_pkg   0.001pf   0.001pf   0.001pf
[Pin]   signal_name   model_name   R_pin   L_pin   C_pin
1   VSS   GND
2   DNU   NC
3   IO8   DQ_18
4   DNU   NC
5   IO9   DQ_18
6   DNU   NC
7   IO10   DQ_18
8   WP#   INPUT_18
9   IO0   DQ_18
10   WE#   INPUT_18
11   IO1   DQ_18
12   ALE   INPUT_18
13   IO2   DQ_18
14   CLE   INPUT_18
15   IO3   DQ_18
16   VSS   GND
17   IO11   DQ_18
18   VSS   GND
19   VCC   POWER
20   DNU   NC
21   VSS   GND
22   DNU   NC
23   VSS   GND
24   VSS   GND
25   VCC   POWER
26   VCC   POWER
27   DNU   NC
28   DNU   NC
29   VCC   POWER
30   VCC   POWER
31   VCC   POWER
32   DNU   NC
33   LOCK   INPUT_18
34   VCC   POWER
35   CE#   INPUT_18
36   IO12   DQ_18
37   RE#   INPUT_18
38   IO4   DQ_18
39   VCC   POWER
40   IO5   DQ_18
41   IO6   DQ_18
42   IO7   DQ_18
43   VCC   POWER
44   IO13   DQ_18
45   VSS   GND
46   IO14   DQ_18
47   VSS   GND
48   IO15   DQ_18
49   RB#   RDBY_OD_18
50   VCC   POWER
51   VSS   GND
52   VSS   GND
|***********************MODEL SELECTOR**************************************
[Model Selector] DQ_33
DQ_FULL_33   Full-Strength IO Driver (VCC=2.7-3.6)
DQ_3QTR_33   3/4 Drive Strength IO Driver (VCC=2.7-3.6)
DQ_HALF_33   1/2 Drive Strength IO Driver (VCC=2.7-3.6)
DQ_QTR_33   1/4 Drive Strength IO Driver (VCC=2.7-3.6)
[Model Selector] RDBY_OD_33
RDBY_FULL_33   Full-Strength RD_BY Driver (VCC=2.7-3.6)
RDBY_3QTR_33   3/4 Drive Strength RD_BY Driver (VCC=2.7-3.6)
RDBY_HALF_33   1/2 Drive Strength RD_BY Driver (VCC=2.7-3.6)
RDBY_QTR_33   1/4 Drive Strength RD_BY Driver (VCC=2.7-3.6)
[Model Selector] DQ_18
DQ_FULL_18   Full-Strength IO Driver (VCC=1.65-1.95)
DQ_3QTR_18   3/4 Drive Strength IO Driver (VCC=1.65-1.95)
DQ_HALF_18   1/2 Drive Strength IO Driver (VCC=1.65-1.95)
DQ_QTR_18   1/4 Drive Strength IO Driver (VCC=1.65-1.95)
[Model Selector] RDBY_OD_18
RDBY_FULL_18   Full-Strength RD_BY Driver (VCC=1.65-1.95)
RDBY_3QTR_18   3/4 Drive Strength RD_BY Driver (VCC=1.65-1.95)
RDBY_HALF_18   1/2 Drive Strength RD_BY Driver (VCC=1.65-1.95)
RDBY_QTR_18   1/4 Drive Strength RD_BY Driver (VCC=1.65-1.95)
|   Sparse Matrix Package Model for 63-Ball VFBGA Package
[Define Package Model]  M59A_VFBGA_FULL_PKG
[Manufacturer]  Micron Technology, Inc.
[OEM]   Micron Technology, Inc.
[Description]   63-Ball 10.5mm x 13mm VFBGA Package
[Number of Pins]   28
[Pin Numbers]
C3
C4
C5
C6
C7
C8
D3
D4
D5
G3
G5
G6
G7
G8
H3
H4
H5
H6
H7
J3
J4
J5
J7
J8
K4
K5
K6
K7
[Model Data]
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[End Model Data]
[End Package Model]
| Models and submodels in the file (18): DQ_FULL_33 (I/O), DQ_3QTR_33 (I/O), DQ_HALF_33 (I/O), DQ_QTR_33 (I/O), INPUT_33 (Input), RDBY_FULL_33 (Open_drain), RDBY_3QTR_33 (Open_drain), RDBY_HALF_33 (Open_drain), RDBY_QTR_33 (Open_drain), DQ_FULL_18 (I/O), DQ_3QTR_18 (I/O), DQ_HALF_18 (I/O), DQ_QTR_18 (I/O), INPUT_18 (Input), RDBY_FULL_18 (Open_drain), RDBY_3QTR_18 (Open_drain), RDBY_HALF_18 (Open_drain), RDBY_QTR_18 (Open_drain)

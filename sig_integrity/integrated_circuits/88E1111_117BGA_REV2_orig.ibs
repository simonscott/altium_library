|   ___.  ___.
|   / . | / . |
|   / /|=|/ /|=|   IBIS model for 88E1111 Rev B2, 117L TFBGA
|  /_/ |___/ |_|
|  M A R V E L L
|  MARVELL SEMICONDUCTOR, INC.
|  Proprietary Information - NDA Required
|  Doc. No. MV-S900067-IM Rev. A
|  88E1111 Rev B2 117 TFBGA Package IBIS Model
[IBIS ver]   3.2
[File name]  88E1111_117BGA_REV2.ibs
[File Rev]   1.3
[Date]   25 July 2008
[Source]   From TSMC 0.13u spice models.
[Notes]   The package used is 117L, TFBGA, 10x14, 4L
   This is for revision B2
   June 26, 2007 :
   Version 1.2 Added four sgmii amplitude options
   July 25, 2008 :
   Version 1.3 Added modified e1111_hsoutxx
   Cref = 5pF
   Vt has more points
[Disclaimer] Information being transmitted is intended only for
             the use of customers of Marvell Technology Group, LTD.
             No responsibility is assumed by Marvell Technology
             Group, LTD., or any of its affiliates, for use of the
             information, nor that the Information infringes any
             intellectual property rights of third parties resulting
             from its use. No license is under any intellectual
             property rights of Marvell Technology Group, LTD.,
             or any of its affiliates. Marvell reserves the right
             to make changes in specification of the Information
             withsout notice. ALL RIGHTS RESERVED.
[Copyright]  Copyright 2008 Marvell Semiconductor Inc.
|   Component e1111
[Component]   e1111
[Manufacturer]   Marvell Semiconductor
[Package]
| Use values for individual pins instead
|   typ   min   max
R_pkg   0.614   0.403   0.775
L_pkg   5.320nH 3.290nH 7.652nH
C_pkg   0.655pF 0.251pF 1.177pF
[pin]   signal_name   model_name   R_pin   L_pin   C_pin
| ball_name   = ball name of a pin in the package
| signal_name = signal name of the pin on data sheet
| model_name  = pad cell used, except POWER, GND and NC
| ball_name signal_name model_name   R_pin   L_pin   C_pin
A1   rxd[5]   e1111_hsout   437.0m   3.205nH   1.300pF
A2   rxd[6]   e1111_hsout   409.1m   2.889nH   1.129pF
A3   rxp   e1111_sgmiirx   440.0m   3.246nH   1.332pF
A4   rxn   e1111_sgmiirx   430.9m   3.135nH   1.263pF
A5   tcp   e1111_sgmii   397.4m   2.748nH   1.037pF
A6   tcn   e1111_sgmii   393.4m   2.684nH   0.989pF
A7   txp   e1111_sgmii   393.1m   2.653nH   0.958pF
A8   txn   e1111_sgmii   395.3m   2.671nH   0.955pF
A9   led_link1000  e1111_led   418.1m   2.914nH   1.118pF
B1   rx_dv   e1111_hsout   429.9m   3.014nH   1.141pF
B2   rxd[0]   e1111_hsout   440.5m   3.185nH   1.611pF
B3   rxd[3]   e1111_hsout   406.0m   2.860nH   1.624pF
B4   vddo   POWER   44.1m   0.383nH   NA
B5   crs   e1111_hsout   335.7m   2.084nH   1.184pF
B6   col   e1111_cob3a   340.8m   2.138nH   0.970pF
B7   avddf   POWER   358.6m   2.235nH   0.951pF
B8   led_link100   e1111_led   401.1m   2.719nH   1.243pF
B9   vddoh   POWER   57.0m   0.460nH   NA
C1   rx_clk   e1111_hsout   429.2m   2.923nH   1.041pF
C2   vddo   POWER   44.1m   0.383nH   NA
C3   rxd[2]   e1111_hsout   356.6m   2.240nH   1.556pF
C4   rxd[4]   e1111_hsout   390.2m   2.700nH   1.737pF
C5   rxd[7]   e1111_hsout   353.5m   2.306nH   1.301pF
C6   dvdd   POWER   8.2m   0.083nH   NA
C7   dvdd   POWER   8.2m   0.083nH   NA
C8   led_link10   e1111_led   368.2m   2.315nH   1.162pF
C9   led_rx   e1111_led   398.2m   2.704nH   0.973pF
D1   tx_clk   e1111_hsout   416.4m   2.788nH   1.019pF
D2   rx_er   e1111_hsout   402.3m   2.626nH   1.123pF
D3   rxd[1]   e1111_hsout   375.1m   2.413nH   1.274pF
D4   vss   GND   4.2m   0.045nH   NA
D5   vss   GND   4.2m   0.045nH   NA
D6   vss   GND   4.2m   0.045nH   NA
D7   dvdd   POWER   8.2m   0.083nH   NA
D8   config[0]   e1111_cin0a   402.7m   2.816nH   1.402pF
D9   led_tx   e1111_led   390.5m   2.599nH   0.907pF
E1   tx_en   e1111_cindat0   376.4m   2.549nH   0.927pF
E2   gtx_clk   e1111_cinclkg   400.9m   2.844nH   1.464pF
E3   dvdd   POWER   8.2m   0.083nH   NA
E4   vss   GND   4.2m   0.045nH   NA
E5   vss   GND   4.2m   0.045nH   NA
E6   vss   GND   4.2m   0.045nH   NA
E7   dvdd   POWER   8.2m   0.083nH   NA
E8   led_duplex   e1111_led   341.2m   2.052nH   0.995pF
E9   config[1]   e1111_cin0a   382.4m   2.548nH   0.889pF
F1   txd[0]   e1111_cindat0   366.7m   2.402nH   0.830pF
F2   tx_er   e1111_cindat0   338.3m   2.099nH   0.888pF
F3   dvdd   POWER   8.2m   0.083nH   NA
F4   vss   GND   4.2m   0.045nH   NA
F5   vss   GND   4.2m   0.045nH   NA
F6   vss   GND   4.2m   0.045nH   NA
F7   vddoh   POWER   57.0m   0.460nH   NA
F8   config[2]   e1111_cin0a   379.0m   2.560nH   1.245pF
F9   config[4]   e1111_cin0a   367.7m   2.391nH   0.805pF
G1   nc   nc   0.0m   0.000nH   NA
G2   txd[1]   e1111_cindat0   339.5m   2.095nH   0.892pF
G3   txd[2]   e1111_cindat0   336.5m   2.103nH   1.202pF
G4   vss   GND   4.2m   0.045nH   NA
G5   vss   GND   4.2m   0.045nH   NA
G6   vss   GND   4.2m   0.045nH   NA
G7   config[3]   e1111_cin0a   347.4m   2.182nH   1.270pF
G8   config[6]   e1111_cin0a   363.5m   2.389nH   1.147pF
G9   config[5]   e1111_cin0a   363.2m   2.343nH   0.773pF
H1   txd[4]   e1111_cindat0   354.8m   2.285nH   0.762pF
H2   txd[3]   e1111_cindat0   371.4m   2.499nH   1.264pF
H3   txd[5]   e1111_cindat0   379.7m   2.617nH   1.605pF
H4   vss   GND   4.2m   0.045nH   NA
H5   vss   GND   4.2m   0.045nH   NA
H6   vss   GND   4.2m   0.045nH   NA
H7   vssc   GND   339.3m   2.129nH   1.229pF
H8   sel_osc   e1111_ciu0a   327.9m   1.968nH   0.752pF
H9   xtal1   e1111_nomodel   201.9m   1.423nH   0.797pF
J1   txd[6]   e1111_cindat0   367.5m   2.425nH   0.854pF
J2   txd[7]   e1111_cindat0   328.3m   1.996nH   0.820pF
J3   dvdd   POWER   8.2m   0.083nH   NA
J4   vss   GND   4.2m   0.045nH   NA
J5   vss   GND   4.2m   0.045nH   NA
J6   vss   GND   4.2m   0.045nH   NA
J7   dvdd   POWER   8.2m   0.083nH   NA
J8   vddoh   POWER   57.0m   0.460nH   NA
J9   xtal2   e1111_nomodel   353.7m   2.291nH   0.772pF
K1   vddo   POWER   44.1m   0.383nH   NA
K2   clk125   e1111_coo1a   382.6m   2.637nH   1.310pF
K3   reset   e1111_cin0a   349.3m   2.206nH   1.212pF
K4   vss   GND   4.2m   0.045nH   NA
K5   vss   GND   4.2m   0.045nH   NA
K6   vss   GND   4.2m   0.045nH   NA
K7   nc   NC   0.0m   0.000nH   NA
K8   tdo   e1111_coo1a   332.4m   1.995nH   0.802pF
K9   vddox2   POWER   84.8m   0.708nH   NA
L1   int   e1111_coo3a   390.0m   2.684nH   1.005pF
L2   vddox1   POWER   84.8m   0.708nH   NA
L3   mdc   e1111_cin0a   393.0m   2.700nH   1.517pF
L4   coma   e1111_cin0a   366.1m   2.403nH   1.750pF
L5   vss   GND   4.2m   0.045nH   NA
L6   vss   GND   4.2m   0.045nH   NA
L7   tdi   e1111_cin0a   203.5m   1.421nH   1.331pF
L8   tms   e1111_ciu0a   377.5m   2.395nH   0.989pF
L9   tck   e1111_ciu0a   393.3m   2.593nH   0.910pF
M1   mdio   e1111_cob3a   416.5m   2.973nH   1.180pF
M2   rset   e1111_nomodel   320.5m   2.250nH   1.197pF
M3   avdd   POWER   65.8m   0.463nH   NA
M4   avdd   POWER   65.8m   0.463nH   NA
M5   hsdacp   e1111_nomodel   279.3m   1.857nH   0.884pF
M6   hsdacn   e1111_nomodel   281.7m   1.880nH   0.899pF
M7   avdd   POWER   65.8m   0.463nH   NA
M8   avdd   POWER   65.8m   0.463nH   NA
M9   trst   e1111_ciu0a   419.1m   2.863nH   1.063pF
N1   mdip[0]   e1111_nomodel   349.0m   2.634nH   1.167pF
N2   mdin[0]   e1111_nomodel   346.6m   2.622nH   1.171pF
N3   mdip[1]   e1111_nomodel   315.8m   2.282nH   0.971pF
N4   mdin[1]   e1111_nomodel   314.5m   2.269nH   0.969pF
N5   avddh   POWER   303.6m   2.118nH   0.874pF
N6   mdip[2]   e1111_nomodel   317.6m   2.283nH   0.963pF
N7   mdin[2]   e1111_nomodel   321.6m   2.310nH   0.971pF
N8   mdip[3]   e1111_nomodel   363.1m   2.720nH   1.180pF
N9   mdin[3]   e1111_nomodel   362.6m   2.726nH   1.192pF
| Analog differential pins
[Diff Pin] inv_pin vdiff tdelay_typ tdelay_min tdelay_max
| The '+' pin is the Diff_pin and the '-' pin is the inv_pin
A3  A4  0.2  0  0  0  | rx
A5  A6  0.2  0  0  0  | tc
A7  A8  0.2  0  0  0  | tx
M5  M6  0.2  0  0  0  | hsdac
N1  N2  0.2  0  0  0  | mdi[0]
N3  N4  0.2  0  0  0  | mdi[1]
N6  N7  0.2  0  0  0  | mdi[2]
N8  N9  0.2  0  0  0  | mdi[3]
|LED output
[Model Selector] e1111_led
e1111_led15_0   1.5v LED output
e1111_led25_0   2.5v LED output
|CMOS 4mA output
[Model Selector] e1111_coo1a
e1111_co15_1a   1.5v CMOS output
e1111_co25_1a   2.5v CMOS output
|CMOS 12mA output
[Model Selector] e1111_coo3a
e1111_co15_3a   1.5v CMOS output
e1111_co25_3a   2.5v CMOS output
|CMOS 12mA bi-dir
[Model Selector] e1111_cob3a
e1111_cb11_3a   1.1v CMOS Bi-Dir
e1111_cb15_3a   1.5v CMOS Bi-Dir
e1111_cb25_3a   2.5v CMOS Bi-Dir
|CMOS input
[Model Selector] e1111_cin0a
e1111_cin11   1.1v CMOS input
e1111_cin25   2.5v CMOS input
|CMOS input pull-up
[Model Selector] e1111_ciu0a
e1111_ciu11   1.1v CMOS input pull-up
e1111_ciu25   2.5v CMOS input pull-up
|HSTL/SSTL class I output
[Model Selector] e1111_hsout
e1111_hsout25_tt   2.5v SSTL driver calibrated for typ. corner
e1111_hsout25_ss   2.5v SSTL driver calibrated for slow corner
e1111_hsout25_ff   2.5v SSTL driver calibrated for fast corner
e1111_hsout18_tt   1.8v HSTL driver calibrated for typ. corner
e1111_hsout18_ss   1.8v HSTL driver calibrated for slow corner
e1111_hsout18_ff   1.8v HSTL driver calibrated for fast corner
e1111_hsout15_tt   1.5v HSTL driver calibrated for typ. corner
e1111_hsout15_ss   1.5v HSTL driver calibrated for slow corner
e1111_hsout15_ff   1.5v HSTL driver calibrated for fast corner
|CMOS Data Input
[Model Selector] e1111_cindat0
e1111_cin11   1.1v CMOS input
e1111_cin25   2.5v CMOS input
|CMOS Clock Input
[Model Selector] e1111_cinclkg
e1111_cinclkg11   1.1V clock input
e1111_cinclkg25   2.5V clock input
|SerDes Drive
[Model Selector] e1111_sgmii
e1111_sgmii001   amp[2..0] = 001
e1111_sgmii011   amp[2..0] = 011
e1111_sgmii101   amp[2..0] = 101
e1111_sgmii111   amp[2..0] = 111
|   Model e1111_sgmiirx
[Model]   e1111_sgmiirx
Model_type   Terminator
|   typ   min   max
C_comp   1.000pF  0.800pF  1.200pF
[Voltage Range] 1.2   1.15   1.25
[Rpower]   50   55   45
| End [Model] e1111_sgmiirx
|   Model e1111_nomodel
| Dummy for analog pads with No model
[Model]   e1111_nomodel
Model_type   Terminator
C_comp   1pF NA NA
[Voltage Range] 2.5 2.3 2.7
[Ramp]
dV/dt_r 1/1n NA NA
dV/dt_f 1/1n NA NA
| End [Component] e1111
| Models and submodels in the file (30): e1111_cb11_3a (I/O), e1111_cb15_3a (I/O), e1111_cb25_3a (I/O), e1111_cin11 (Input), e1111_cin25 (Input), e1111_cinclkg11 (Input), e1111_cinclkg25 (Input), e1111_ciu11 (Input), e1111_ciu25 (Input), e1111_co15_1a (Output), e1111_co15_3a (Output), e1111_co25_1a (Output), e1111_co25_3a (Output), e1111_hsout15_ff (Output), e1111_hsout15_ss (Output), e1111_hsout15_tt (Output), e1111_hsout18_ff (Output), e1111_hsout18_ss (Output), e1111_hsout18_tt (Output), e1111_hsout25_ff (Output), e1111_hsout25_ss (Output), e1111_hsout25_tt (Output), e1111_led15_0 (Output), e1111_led25_0 (Output), e1111_sgmii001 (Open_drain), e1111_sgmii011 (Open_drain), e1111_sgmii101 (Open_drain), e1111_sgmii111 (Open_drain), e1111_sgmiirx (Terminator), e1111_nomodel (Terminator)

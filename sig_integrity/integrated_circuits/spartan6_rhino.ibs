| / 7\'7
| \ \   Xilinx Inc.
| / /
| \_\/.\   IBIS Models for SPARTAN-6
[IBIS ver]   3.2
[File name]   spartan6_rhino.ibs
[File Rev]   1.3
[Date]   Fri October 15 21:18:24 2010
[Source]   Derived from spice models, rev0.21, using
   hspice 2007.12
[Notes]   Xilinx IBIS file for SPARTAN-6 I/O standards.
   All models are preliminary.
   The version of IBISCHK used is ibischk4.
   Ibis models were generated using S2IBIS3.
[Disclaimer] The data in this file is derived from SPICE simulations using
                 modeling information extracted from the target process. While
                 a great deal of care has been taken to provide information
                 that is accurate, this model is considered preliminary as it
                 has not been verified by actual silicon measurement. Treat the
                 data in this model as preliminary until actual silicon
                 verification is performed.
[Copyright]   Copyright 2009, 2010, Xilinx Inc., All rights reserved
|   Component SPARTAN-6
[Component]   SPARTAN-6
[Manufacturer]   Xilinx Inc.
[Package]
|FGG676
|variable   typ   min   max
R_pkg   148.18m   54.57m   252.88m
L_pkg   5.65nH   2.01nH   12.70nH
C_pkg   1.42pF   0.74pF   2.92pF
[Pin]  signal_name   model_name
D23   mcb5_dram_cke   SSTL15_II_LR_25
F24   mcb5_dram_dqs   SSTL15_II_LR_25
R6   FMC1_CLK0_M2C   LVCMOS25_S_12_LR_25
B2   mcb4_dram_ba<0>   SSTL15_II_LR_25
R26   FPGA_PROC_BUS_CLK   LVCMOS33_S_12_LR_25
B1   mcb4_dram_ba<1>   SSTL15_II_LR_25
K22   mcb5_dram_odt   SSTL15_II_LR_25
G3   mcb4_dram_ba<2>   SSTL15_II_LR_25
D13   FMC1_LA_N<0>   LVDS_25_TB_25
A13   FMC1_LA_N<1>   LVDS_25_TB_25
G8   FMC1_LA_N<2>   LVDS_25_TB_25
R1   FMC1_CLK1_M2C   LVCMOS25_S_12_LR_25
F6   FMC1_LA_N<3>   LVDS_25_TB_25
B3   FMC1_LA_N<4>   LVDS_25_TB_25
F5   FMC1_LA_N<5>   LVDS_25_TB_25
E5   FMC1_LA_N<6>   LVDS_25_TB_25
G9   FMC1_LA_N<7>   LVDS_25_TB_25
J23   mcb5_dram_udm   SSTL15_II_LR_25
E13   FMC1_LA_P<0>   LVDS_25_TB_25
A2   FMC1_LA_N<8>   LVDS_25_TB_25
C13   FMC1_LA_P<1>   LVDS_25_TB_25
E8   FMC1_LA_N<9>   LVDS_25_TB_25
H8   FMC1_LA_P<2>   LVDS_25_TB_25
W3   GIGE_RX_CLK   LVCMOS25_S_12_LR_25
F7   FMC1_LA_P<3>   LVDS_25_TB_25
L19   mcb5_dram_ba<0>   SSTL15_II_LR_25
C3   FMC1_LA_P<4>   LVDS_25_TB_25
K20   mcb5_dram_ba<1>   SSTL15_II_LR_25
G6   FMC1_LA_P<5>   LVDS_25_TB_25
J22   mcb5_dram_ba<2>   SSTL15_II_LR_25
N17   FPGA_PROC_BUS_A<1>   LVCMOS33_S_12_LR_25
E6   FMC1_LA_P<6>   LVDS_25_TB_25
N18   FPGA_PROC_BUS_A<2>   LVCMOS33_S_12_LR_25
H9   FMC1_LA_P<7>   LVDS_25_TB_25
L23   FPGA_PROC_BUS_A<3>   LVCMOS33_S_12_LR_25
A3   FMC1_LA_P<8>   LVDS_25_TB_25
L24   FPGA_PROC_BUS_A<4>   LVCMOS33_S_12_LR_25
F9   FMC1_LA_P<9>   LVDS_25_TB_25
N19   FPGA_PROC_BUS_A<5>   LVCMOS33_S_12_LR_25
N20   FPGA_PROC_BUS_A<6>   LVCMOS33_S_12_LR_25
N21   FPGA_PROC_BUS_A<7>   LVCMOS33_S_12_LR_25
N22   FPGA_PROC_BUS_A<8>   LVCMOS33_S_12_LR_25
P17   FPGA_PROC_BUS_A<9>   LVCMOS33_S_12_LR_25
AC23   FPGA_AWAKE   LVCMOS33_S_12_LR_25
N23   FPGA_PROC_BUS_D<0>   LVCMOS33_S_12_LR_25
N24   FPGA_PROC_BUS_D<1>   LVCMOS33_S_12_LR_25
R18   FPGA_PROC_BUS_D<2>   LVCMOS33_S_12_LR_25
R19   FPGA_PROC_BUS_D<3>   LVCMOS33_S_12_LR_25
P21   FPGA_PROC_BUS_D<4>   LVCMOS33_S_12_LR_25
P22   FPGA_PROC_BUS_D<5>   LVCMOS33_S_12_LR_25
R20   FPGA_PROC_BUS_D<6>   LVCMOS33_S_12_LR_25
R21   FPGA_PROC_BUS_D<7>   LVCMOS33_S_12_LR_25
P24   FPGA_PROC_BUS_D<8>   LVCMOS33_S_12_LR_25
P26   FPGA_PROC_BUS_D<9>   LVCMOS33_S_12_LR_25
P8   FMC0_ZDOK_N<0>   BLVDS_25_LR_25
N4   FMC0_ZDOK_N<1>   BLVDS_25_LR_25
AA6   FMC0_ZDOK_N<2>   BLVDS_25_TB_25
AF4   FMC0_ZDOK_N<3>   BLVDS_25_TB_25
T1   GIGE_TX_CLK   LVCMOS25_S_12_LR_25
J5   mcb4_dram_ck_n   SSTL15_II_LR_25
A22   FMC1_ZDOK_N<0>   BLVDS_25_TB_25
U24   IEEE1588_CLK   LVCMOS33_S_12_LR_25
R9   FMC0_ZDOK_P<0>   BLVDS_25_LR_25
F19   FMC1_ZDOK_N<1>   BLVDS_25_TB_25
N5   FMC0_ZDOK_P<1>   BLVDS_25_LR_25
A23   FMC1_ZDOK_N<2>   BLVDS_25_TB_25
AA7   FMC0_ZDOK_P<2>   BLVDS_25_TB_25
D22   FMC1_ZDOK_N<3>   BLVDS_25_TB_25
AD4   FMC0_ZDOK_P<3>   BLVDS_25_TB_25
B26   mcb5_dram_ck_n   SSTL15_II_LR_25
B22   FMC1_ZDOK_P<0>   BLVDS_25_TB_25
G19   FMC1_ZDOK_P<1>   BLVDS_25_TB_25
R8   GPIO<0>   LVCMOS25_S_12_LR_25
B23   FMC1_ZDOK_P<2>   BLVDS_25_TB_25
T8   GPIO<1>   LVCMOS25_S_12_LR_25
D21   FMC1_ZDOK_P<3>   BLVDS_25_TB_25
U5   GPIO<2>   LVCMOS25_S_12_LR_25
T4   GPIO<3>   LVCMOS25_S_12_LR_25
R10   GPIO<4>   LVCMOS25_S_12_LR_25
T9   GPIO<5>   LVCMOS25_S_12_LR_25
P3   GPIO<6>   LVCMOS25_S_12_LR_25
P1   GPIO<7>   LVCMOS25_S_12_LR_25
AC2   GIGE_COL   LVCMOS25_S_12_LR_25
N6   GPIO<8>   LVCMOS25_S_12_LR_25
P6   GPIO<9>   LVCMOS25_S_12_LR_25
AC1   GIGE_MDC   LVCMOS25_S_12_LR_25
AD1   GIGE_CRS   LVCMOS25_S_12_LR_25
C5   FMC1_LA_N<10>   LVDS_25_TB_25
G10   FMC1_LA_N<11>   LVDS_25_TB_25
A4   FMC1_LA_N<12>   LVDS_25_TB_25
J12   FMC1_LA_N<20>   LVDS_25_TB_25
H3   mcb4_dram_dq<0>   SSTL15_II_LR_25
E10   FMC1_LA_N<13>   LVDS_25_TB_25
H13   FMC1_LA_N<21>   LVDS_25_TB_25
H1   mcb4_dram_dq<1>   SSTL15_II_LR_25
A5   FMC1_LA_N<14>   LVDS_25_TB_25
E14   FMC1_LA_N<22>   LVDS_25_TB_25
E20   FMC1_LA_N<30>   LVDS_25_TB_25
G2   mcb4_dram_dq<2>   SSTL15_II_LR_25
F11   FMC1_LA_N<15>   LVDS_25_TB_25
H14   FMC1_LA_N<23>   LVDS_25_TB_25
G17   FMC1_LA_N<31>   LVDS_25_TB_25
G1   mcb4_dram_dq<3>   SSTL15_II_LR_25
E12   FMC1_LA_N<16>   LVDS_25_TB_25
H15   FMC1_LA_N<24>   LVDS_25_TB_25
B21   FMC1_LA_N<32>   LVDS_25_TB_25
D3   mcb4_dram_dq<4>   SSTL15_II_LR_25
A12   FMC1_LA_N<17>   LVDS_25_TB_25
J17   FMC1_LA_N<25>   LVDS_25_TB_25
H19   FMC1_LA_N<33>   LVDS_25_TB_25
D1   mcb4_dram_dq<5>   SSTL15_II_LR_25
G11   FMC1_LA_N<18>   LVDS_25_TB_25
E16   FMC1_LA_N<26>   LVDS_25_TB_25
E2   mcb4_dram_dq<6>   SSTL15_II_LR_25
AA25   FPGA_PROC_BUS_nOE   LVCMOS33_S_12_LR_25
G13   FMC1_LA_N<19>   LVDS_25_TB_25
F15   FMC1_LA_N<27>   LVDS_25_TB_25
E1   mcb4_dram_dq<7>   SSTL15_II_LR_25
E18   FMC1_LA_N<28>   LVDS_25_TB_25
J2   mcb4_dram_dq<8>   SSTL15_II_LR_25
F17   FMC1_LA_N<29>   LVDS_25_TB_25
J1   mcb4_dram_dq<9>   SSTL15_II_LR_25
D5   FMC1_LA_P<10>   LVDS_25_TB_25
W26   FPGA_PROC_BUS_nWE   LVCMOS33_S_12_LR_25
H10   FMC1_LA_P<11>   LVDS_25_TB_25
G25   mcb5_dram_dq<0>   SSTL15_II_LR_25
B4   FMC1_LA_P<12>   LVDS_25_TB_25
K12   FMC1_LA_P<20>   LVDS_25_TB_25
G26   mcb5_dram_dq<1>   SSTL15_II_LR_25
F10   FMC1_LA_P<13>   LVDS_25_TB_25
J13   FMC1_LA_P<21>   LVDS_25_TB_25
H24   mcb5_dram_dq<2>   SSTL15_II_LR_25
B5   FMC1_LA_P<14>   LVDS_25_TB_25
F14   FMC1_LA_P<22>   LVDS_25_TB_25
F20   FMC1_LA_P<30>   LVDS_25_TB_25
H26   mcb5_dram_dq<3>   SSTL15_II_LR_25
G12   FMC1_LA_P<15>   LVDS_25_TB_25
K14   FMC1_LA_P<23>   LVDS_25_TB_25
H17   FMC1_LA_P<31>   LVDS_25_TB_25
E25   mcb5_dram_dq<4>   SSTL15_II_LR_25
F12   FMC1_LA_P<16>   LVDS_25_TB_25
J15   FMC1_LA_P<24>   LVDS_25_TB_25
C21   FMC1_LA_P<32>   LVDS_25_TB_25
AD24   FPGA_PROC_BUS_nWP   LVCMOS33_S_12_LR_25
E26   mcb5_dram_dq<5>   SSTL15_II_LR_25
B12   FMC1_LA_P<17>   LVDS_25_TB_25
J16   FMC1_LA_P<25>   LVDS_25_TB_25
H18   FMC1_LA_P<33>   LVDS_25_TB_25
D24   mcb5_dram_dq<6>   SSTL15_II_LR_25
J11   FMC1_LA_P<18>   LVDS_25_TB_25
F16   FMC1_LA_P<26>   LVDS_25_TB_25
D26   mcb5_dram_dq<7>   SSTL15_II_LR_25
H12   FMC1_LA_P<19>   LVDS_25_TB_25
G15   FMC1_LA_P<27>   LVDS_25_TB_25
K24   mcb5_dram_dq<8>   SSTL15_II_LR_25
P19   FPGA_PROC_BUS_A<10>  LVCMOS33_S_12_LR_25
F18   FMC1_LA_P<28>   LVDS_25_TB_25
K26   mcb5_dram_dq<9>   SSTL15_II_LR_25
G16   FMC1_LA_P<29>   LVDS_25_TB_25
G4   mcb4_dram_we_n   SSTL15_II_LR_25
AD23   CONF_DIN   LVCMOS25_S_12_TB_25
J20   mcb5_dram_we_n   SSTL15_II_LR_25
R23   FPGA_PROC_BUS_D<10>  LVCMOS33_S_12_LR_25
L2   mcb4_dram_udqs   SSTL15_II_LR_25
R24   FPGA_PROC_BUS_D<11>  LVCMOS33_S_12_LR_25
E4   mcb4_dram_reset_n   SSTL15_II_LR_25
T22   FPGA_PROC_BUS_D<12>  LVCMOS33_S_12_LR_25
T23   FPGA_PROC_BUS_D<13>  LVCMOS33_S_12_LR_25
U23   FPGA_PROC_BUS_D<14>  LVCMOS33_S_12_LR_25
R25   FPGA_PROC_BUS_D<15>  LVCMOS33_S_12_LR_25
M24   mcb5_dram_udqs   SSTL15_II_LR_25
AA26   FPGA_PROC_BUS__V_ALE LVCMOS33_S_12_LR_25
AC25   FP_I2C_SDA   LVCMOS33_S_12_LR_25
AC26   FP_I2C_SCL   LVCMOS33_S_12_LR_25
P5   GPIO<10>   LVCMOS25_S_12_LR_25
K18   mcb5_dram_reset_n   SSTL15_II_LR_25
L8   mcb4_dram_cas_n   SSTL15_II_LR_25
R5   GPIO<11>   LVCMOS25_S_12_LR_25
N8   GPIO<12>   LVCMOS25_S_12_LR_25
N7   GPIO<13>   LVCMOS25_S_12_LR_25
R4   GPIO<14>   LVCMOS25_S_12_LR_25
R3   GPIO<15>   LVCMOS25_S_12_LR_25
AE3   CONF_INIT_B   LVCMOS25_S_12_TB_25
G24   mcb5_dram_cas_n   SSTL15_II_LR_25
AA1   GIGE_COMA   LVCMOS25_S_12_LR_25
V5   GIGE_RX_ER   LVCMOS25_S_12_LR_25
U3   GIGE_RX_DV   LVCMOS25_S_12_LR_25
K9   mcb4_dram_cke   SSTL15_II_LR_25
K3   mcb4_dram_dq<10>   SSTL15_II_LR_25
K1   mcb4_dram_dq<11>   SSTL15_II_LR_25
M3   mcb4_dram_dq<12>   SSTL15_II_LR_25
AC4   GIGE_TX_EN   LVCMOS25_F_12_LR_25
M1   mcb4_dram_dq<13>   SSTL15_II_LR_25
N2   mcb4_dram_dq<14>   SSTL15_II_LR_25
AA4   GIGE_TX_ER   LVCMOS25_F_12_LR_25
N1   mcb4_dram_dq<15>   SSTL15_II_LR_25
V23   FPGA_PROC_BUS_nCS0   LVCMOS33_S_12_LR_25
AE2   GIGE_MDIO   LVCMOS25_S_12_LR_25
U25   FPGA_PROC_BUS_nCS1   LVCMOS33_S_12_LR_25
T24   FPGA_PROC_BUS_nCS2   LVCMOS33_S_12_LR_25
T26   FPGA_PROC_BUS_nCS3   LVCMOS33_S_12_LR_25
V24   FPGA_PROC_BUS_nCS4   LVCMOS33_S_12_LR_25
V26   FPGA_PROC_BUS_nCS5   LVCMOS33_S_12_LR_25
W25   FPGA_PROC_BUS_nCS6   LVCMOS33_S_12_LR_25
F3   mcb4_dram_dqs   SSTL15_II_LR_25
AB5   GIGE_GTX_CLK   LVCMOS25_F_12_LR_25
AE25   IEEE1588_GPIO<0>   LVCMOS33_S_12_LR_25
AE26   IEEE1588_GPIO<1>   LVCMOS33_S_12_LR_25
W24   FMC0_CLK0_M2C   LVCMOS33_S_12_LR_25
U21   IEEE1588_GPIO<2>   LVCMOS33_S_12_LR_25
H6   mcb4_zio   SSTL15_II_LR_25
U22   IEEE1588_GPIO<3>   LVCMOS33_S_12_LR_25
M4   mcb4_rzq   SSTL15_II_LR_25
M6   mcb4_dram_odt   SSTL15_II_LR_25
U26   FMC0_CLK1_M2C   LVCMOS33_S_12_LR_25
H20   mcb5_zio   SSTL15_II_LR_25
M21   mcb5_rzq   SSTL15_II_LR_25
J4   mcb4_dram_udm   SSTL15_II_LR_25
J25   mcb5_dram_dq<10>   SSTL15_II_LR_25
F1   mcb4_dram_dqs_n   SSTL15_II_LR_25
J26   mcb5_dram_dq<11>   SSTL15_II_LR_25
L25   mcb5_dram_dq<12>   SSTL15_II_LR_25
L26   mcb5_dram_dq<13>   SSTL15_II_LR_25
N25   mcb5_dram_dq<14>   SSTL15_II_LR_25
N26   mcb5_dram_dq<15>   SSTL15_II_LR_25
F26   mcb5_dram_dqs_n   SSTL15_II_LR_25
L9   mcb4_dram_ras_n   SSTL15_II_LR_25
AE24   CONF_CCLK   LVCMOS25_S_12_TB_25
L1   mcb4_dram_udqs_n   SSTL15_II_LR_25
AD26   FPGA_PROC_BUS_BUSY0  LVCMOS33_S_12_LR_25
T19   FMC_I2C_SDA   LVCMOS33_S_12_LR_25
AB24   FPGA_PROC_BUS_BUSY1  LVCMOS33_S_12_LR_25
K5   mcb4_dram_ck   SSTL15_II_LR_25
J3   mcb4_dram_dm   SSTL15_II_LR_25
T20   FMC_I2C_SCL   LVCMOS33_S_12_LR_25
V20   nFMC0_PRSNT   LVCMOS33_S_12_LR_25
F23   mcb5_dram_ras_n   SSTL15_II_LR_25
AB19   FMC0_LA_N<10>   LVDS_25_TB_25
J9   mcb4_dram_a<10>   SSTL15_II_LR_25
Y16   FMC0_LA_N<11>   LVDS_25_TB_25
E3   mcb4_dram_a<11>   SSTL15_II_LR_25
AB17   FMC0_LA_N<12>   LVDS_25_TB_25
Y13   FMC0_LA_N<20>   LVDS_25_TB_25
Y3   USER_LED<0>   LVCMOS25_S_24_LR_25
K8   mcb4_dram_a<12>   SSTL15_II_LR_25
AA16   FMC0_LA_N<13>   LVDS_25_TB_25
W12   FMC0_LA_N<21>   LVDS_25_TB_25
Y1   USER_LED<1>   LVCMOS25_S_24_LR_25
K7   mcb4_dram_a<13>   SSTL15_II_LR_25
V15   FMC0_LA_N<14>   LVDS_25_TB_25
AA13   FMC0_LA_N<22>   LVDS_25_TB_25
AA8   FMC0_LA_N<30>   LVDS_25_TB_25
W2   USER_LED<2>   LVCMOS25_S_24_LR_25
V13   FMC0_LA_N<15>   LVDS_25_TB_25
AA11   FMC0_LA_N<23>   LVDS_25_TB_25
AC6   FMC0_LA_N<31>   LVDS_25_TB_25
W1   USER_LED<3>   LVCMOS25_S_24_LR_25
AB15   FMC0_LA_N<16>   LVDS_25_TB_25
V10   FMC0_LA_N<24>   LVDS_25_TB_25
AD5   FMC0_LA_N<32>   LVDS_25_TB_25
V3   USER_LED<4>   LVCMOS25_S_24_LR_25
AF13   FMC0_LA_N<17>   LVDS_25_TB_25
AB9   FMC0_LA_N<25>   LVDS_25_TB_25
W7   FMC0_LA_N<33>   LVDS_25_TB_25
V1   USER_LED<5>   LVCMOS25_S_24_LR_25
AF14   FMC0_LA_N<18>   LVDS_25_TB_25
AB11   FMC0_LA_N<26>   LVDS_25_TB_25
U2   USER_LED<6>   LVCMOS25_S_24_LR_25
AA12   FMC0_LA_N<19>   LVDS_25_TB_25
AF6   FMC0_LA_N<27>   LVDS_25_TB_25
U1   USER_LED<7>   LVCMOS25_S_24_LR_25
W9   FMC0_LA_N<28>   LVDS_25_TB_25
AF5   FMC0_LA_N<29>   LVDS_25_TB_25
AA2   GIGE_nRESET   LVCMOS25_S_12_LR_25
M26   mcb5_dram_udqs_n   SSTL15_II_LR_25
F22   mcb5_dram_a<10>   SSTL15_II_LR_25
AA19   FMC0_LA_P<10>   LVDS_25_TB_25
K19   mcb5_dram_a<11>   SSTL15_II_LR_25
W16   FMC0_LA_P<11>   LVDS_25_TB_25
C24   mcb5_dram_a<12>   SSTL15_II_LR_25
AA18   FMC0_LA_P<12>   LVDS_25_TB_25
W14   FMC0_LA_P<20>   LVDS_25_TB_25
B24   mcb5_dram_a<13>   SSTL15_II_LR_25
Y15   FMC0_LA_P<13>   LVDS_25_TB_25
V12   FMC0_LA_P<21>   LVDS_25_TB_25
V14   FMC0_LA_P<14>   LVDS_25_TB_25
AB13   FMC0_LA_P<22>   LVDS_25_TB_25
Y9   FMC0_LA_P<30>   LVDS_25_TB_25
U13   FMC0_LA_P<15>   LVDS_25_TB_25
Y11   FMC0_LA_P<23>   LVDS_25_TB_25
AB7   FMC0_LA_P<31>   LVDS_25_TB_25
AA15   FMC0_LA_P<16>   LVDS_25_TB_25
V11   FMC0_LA_P<24>   LVDS_25_TB_25
AC5   FMC0_LA_P<32>   LVDS_25_TB_25
AE13   FMC0_LA_P<17>   LVDS_25_TB_25
AA9   FMC0_LA_P<25>   LVDS_25_TB_25
W8   FMC0_LA_P<33>   LVDS_25_TB_25
AD14   FMC0_LA_P<18>   LVDS_25_TB_25
AA10   FMC0_LA_P<26>   LVDS_25_TB_25
V21   nFMC1_PRSNT   LVCMOS33_S_12_LR_25
Y12   FMC0_LA_P<19>   LVDS_25_TB_25
AD6   FMC0_LA_P<27>   LVDS_25_TB_25
W10   FMC0_LA_P<28>   LVDS_25_TB_25
AE5   FMC0_LA_P<29>   LVDS_25_TB_25
W5   GIGE_RXD<0>   LVCMOS25_S_12_LR_25
U9   GIGE_RXD<1>   LVCMOS25_S_12_LR_25
U8   GIGE_RXD<2>   LVCMOS25_S_12_LR_25
U7   GIGE_RXD<3>   LVCMOS25_S_12_LR_25
T6   GIGE_RXD<4>   LVCMOS25_S_12_LR_25
AB3   GIGE_RXD<5>   LVCMOS25_S_12_LR_25
AB1   GIGE_RXD<6>   LVCMOS25_S_12_LR_25
AD3   GIGE_RXD<7>   LVCMOS25_S_12_LR_25
AF15   FMC0_LA_N<0>   LVDS_25_TB_25
L7   mcb4_dram_a<0>   SSTL15_II_LR_25
AC14   FMC0_LA_N<1>   LVDS_25_TB_25
L6   mcb4_dram_a<1>   SSTL15_II_LR_25
AA22   FMC0_LA_N<2>   LVDS_25_TB_25
K10   mcb4_dram_a<2>   SSTL15_II_LR_25
AA23   FMC0_GA0   LVCMOS33_S_12_LR_25
Y20   FMC0_LA_N<3>   LVDS_25_TB_25
M8   mcb4_dram_a<3>   SSTL15_II_LR_25
AA24   FMC0_GA1   LVCMOS33_S_12_LR_25
AC22   FMC0_LA_N<4>   LVDS_25_TB_25
J7   mcb4_dram_a<4>   SSTL15_II_LR_25
W19   FMC0_LA_N<5>   LVDS_25_TB_25
L4   mcb4_dram_a<5>   SSTL15_II_LR_25
W18   FMC0_LA_N<6>   LVDS_25_TB_25
L3   mcb4_dram_a<6>   SSTL15_II_LR_25
AB21   FMC0_LA_N<7>   LVDS_25_TB_25
L10   mcb4_dram_a<7>   SSTL15_II_LR_25
C25   mcb5_dram_a<0>   SSTL15_II_LR_25
AE15   FMC0_LA_P<0>   LVDS_25_TB_25
AA17   FMC0_LA_N<8>   LVDS_25_TB_25
C2   mcb4_dram_a<8>   SSTL15_II_LR_25
AE1   GIGE_nINT   LVCMOS25_S_12_LR_25
C26   mcb5_dram_a<1>   SSTL15_II_LR_25
AB14   FMC0_LA_P<1>   LVDS_25_TB_25
V16   FMC0_LA_N<9>   LVDS_25_TB_25
C1   mcb4_dram_a<9>   SSTL15_II_LR_25
E24   mcb5_dram_a<2>   SSTL15_II_LR_25
Y21   FMC0_LA_P<2>   LVDS_25_TB_25
K21   mcb5_dram_a<3>   SSTL15_II_LR_25
U19   FMC1_GA0   LVCMOS33_S_12_LR_25
W20   FMC0_LA_P<3>   LVDS_25_TB_25
U20   FMC1_GA1   LVCMOS33_S_12_LR_25
G23   mcb5_dram_a<4>   SSTL15_II_LR_25
AB22   FMC0_LA_P<4>   LVDS_25_TB_25
M18   mcb5_dram_a<5>   SSTL15_II_LR_25
V18   FMC0_LA_P<5>   LVDS_25_TB_25
M19   mcb5_dram_a<6>   SSTL15_II_LR_25
W17   FMC0_LA_P<6>   LVDS_25_TB_25
AA3   GIGE_TXD<0>   LVCMOS25_F_12_LR_25
E23   mcb5_dram_a<7>   SSTL15_II_LR_25
AA21   FMC0_LA_P<7>   LVDS_25_TB_25
Y6   GIGE_TXD<1>   LVCMOS25_F_12_LR_25
H21   mcb5_dram_a<8>   SSTL15_II_LR_25
Y17   FMC0_LA_P<8>   LVDS_25_TB_25
Y5   GIGE_TXD<2>   LVCMOS25_F_12_LR_25
H22   mcb5_dram_a<9>   SSTL15_II_LR_25
U15   FMC0_LA_P<9>   LVDS_25_TB_25
AB4   GIGE_TXD<3>   LVCMOS25_F_12_LR_25
AC3   GIGE_TXD<4>   LVCMOS25_F_12_LR_25
V7   GIGE_TXD<5>   LVCMOS25_F_12_LR_25
V6   GIGE_TXD<6>   LVCMOS25_F_12_LR_25
U4   GIGE_TXD<7>   LVCMOS25_F_12_LR_25
B25   mcb5_dram_ck   SSTL15_II_LR_25
J24   mcb5_dram_dm   SSTL15_II_LR_25
H7   HSWAPEN   LVCMOS25_F_12_TB_25
G7   IO_L1N_VREF_0   NC
B14   GCLK13   NC
A14   GCLK12   NC
A6   MGTTXN0_101   NC
B6   MGTTXP0_101   NC
A10   MGTREFCLK0N_101   NC
B10   MGTREFCLK0P_101   NC
C7   MGTRXN0_101   NC
D7   MGTRXP0_101   NC
C9   MGTRXN1_101   NC
D9   MGTRXP1_101   NC
C11   MGTREFCLK1N_101   NC
D11   MGTREFCLK1P_101   NC
A8   MGTTXN1_101   NC
B8   MGTTXP1_101   NC
A18   MGTTXN0_123   NC
B18   MGTTXP0_123   NC
C15   MGTREFCLK0N_123   NC
D15   MGTREFCLK0P_123   NC
C17   MGTRXN0_123   NC
D17   MGTRXP0_123   NC
C19   MGTRXN1_123   NC
D19   MGTRXP1_123   NC
A16   MGTREFCLK1N_123   NC
B16   MGTREFCLK1P_123   NC
A20   MGTTXN1_123   NC
B20   MGTTXP1_123   NC
G20   A24   LVCMOS25_F_12_TB_25
A25   M5A14   NC
M23   IO_L26N_VREF_5   NC
L20   IO_L27P_5   NC
L21   IO_L27N_5   NC
AB26   M1DQ11   NC
Y24   M1DQ12   NC
Y26   M1DQ13   NC
AC24   DOUT_BUSY   LVCMOS25_F_12_TB_25
AF24   M0_CMPMISO   NC
AF23   MOSI_CSI_B_MISO0   LVCMOS25_F_12_TB_25
AD22   M1   LVCMOS25_F_12_TB_25
AF22   D10   LVCMOS25_F_12_TB_25
AF3   CSO_B   LVCMOS25_F_12_TB_25
AE21   MGTTXP1_267   NC
AF21   MGTTXN1_267   NC
AE17   MGTREFCLK1P_267   NC
AF17   MGTREFCLK1N_267   NC
AC20   MGTRXP1_267   NC
AD20   MGTRXN1_267   NC
AC18   MGTRXP0_267   NC
AD18   MGTRXN0_267   NC
AC16   MGTREFCLK0P_267   NC
AD16   MGTREFCLK0N_267   NC
AE19   MGTTXP0_267   NC
AF19   MGTTXN0_267   NC
AE9   MGTTXP1_245   NC
AF9   MGTTXN1_245   NC
AC12   MGTREFCLK1P_245   NC
AD12   MGTREFCLK1N_245   NC
AC10   MGTRXP1_245   NC
AD10   MGTRXN1_245   NC
AC8   MGTRXP0_245   NC
AD8   MGTRXN0_245   NC
AE11   MGTREFCLK0P_245   NC
AF11   MGTREFCLK0N_245   NC
AE7   MGTTXP0_245   NC
AF7   MGTTXN0_245   NC
T3   GCLK27_M3DQ4   NC
V4   GCLK25_TRDY2_M3UDM   NC
R7   GCLK23_M3RASN   NC
R2   GCLK21_M3A5   NC
P10   M3A13   NC
N9   M3A14   NC
M10   IO_L57P_3   NC
M9   IO_L57N_VREF_3   NC
N3   IO_L58N_VREF_4   NC
K6   M4A14   NC
H5   IO_L83N_VREF_4   NC
A24   TCK   LVCMOS25_S_8_TB_25
C23   TDI   LVCMOS25_S_8_TB_25
B11   MGTAVCCPLL0_101   NC
E9   MGTRREF_101   NC
E11   MGTAVTTRCAL_101   NC
C12   MGTAVCCPLL1_101   NC
C14   MGTAVCCPLL0_123   NC
B15   MGTAVCCPLL1_123   NC
F21   TMS   LVCMOS25_S_8_TB_25
G21   TDO   LVCMOS25_S_8_TB_25
W22   VFS   NC
V19   RFUSE   NC
V22   VBATT   NC
Y22   SUSPEND   LVCMOS25_S_8_TB_25
Y19   CMPCS_B_2   NC
AF25   DONE_2   LVCMOS25_S_8_TB_25
AF2   PROGRAM_B_2   LVCMOS25_S_8_TB_25
AE16   MGTAVCCPLL1_267   NC
AD15   MGTAVCCPLL0_267   NC
AD13   MGTAVCCPLL1_245   NC
AB12   MGTAVTTRCAL_245   NC
AB10   MGTRREF_245   NC
AE12   MGTAVCCPLL0_245   NC
A1   GND   GND
A11   GND   GND
A15   GND   GND
A17   GND   GND
A21   GND   GND
A26   GND   GND
A9   GND   GND
AB16   GND   GND
AB2   GND   GND
AB20   GND   GND
AB25   GND   GND
AC11   GND   GND
AC13   GND   GND
AC15   GND   GND
AC17   GND   GND
AD19   GND   GND
AD21   GND   GND
AD7   GND   GND
AD9   GND   GND
AE10   GND   GND
AE18   GND   GND
AE20   GND   GND
AE22   GND   GND
AE6   GND   GND
AE8   GND   GND
AF1   GND   GND
AF10   GND   GND
AF12   GND   GND
AF16   GND   GND
AF18   GND   GND
AF26   GND   GND
B17   GND   GND
B19   GND   GND
B7   GND   GND
B9   GND   GND
C18   GND   GND
C20   GND   GND
C6   GND   GND
C8   GND   GND
D10   GND   GND
D12   GND   GND
D14   GND   GND
D16   GND   GND
D4   GND   GND
E15   GND   GND
E19   GND   GND
E22   GND   GND
E7   GND   GND
F2   GND   GND
F25   GND   GND
G14   GND   GND
H23   GND   GND
H4   GND   GND
J19   GND   GND
J8   GND   GND
K16   GND   GND
K2   GND   GND
K25   GND   GND
L11   GND   GND
L13   GND   GND
L15   GND   GND
L17   GND   GND
M22   GND   GND
M5   GND   GND
N11   GND   GND
N14   GND   GND
P13   GND   GND
P16   GND   GND
P2   GND   GND
P20   GND   GND
P25   GND   GND
P7   GND   GND
T10   GND   GND
T12   GND   GND
T14   GND   GND
T16   GND   GND
T18   GND   GND
T21   GND   GND
T5   GND   GND
U11   GND   GND
U17   GND   GND
V2   GND   GND
V25   GND   GND
V8   GND   GND
Y10   GND   GND
Y14   GND   GND
Y23   GND   GND
Y4   GND   GND
Y7   GND   GND
B13   VCCO_0   POWER
C22   VCCO_0   POWER
C4   VCCO_0   POWER
E21   VCCO_0   POWER
F13   VCCO_0   POWER
F8   VCCO_0   POWER
G18   VCCO_0   POWER
H11   VCCO_0   POWER
H16   VCCO_0   POWER
J14   VCCO_0   POWER
AA5   VCCAUX   POWER
AB18   VCCAUX   POWER
AB8   VCCAUX   POWER
AC21   VCCAUX   POWER
AC7   VCCAUX   POWER
D20   VCCAUX   POWER
D6   VCCAUX   POWER
E17   VCCAUX   POWER
G5   VCCAUX   POWER
J10   VCCAUX   POWER
J18   VCCAUX   POWER
K13   VCCAUX   POWER
K15   VCCAUX   POWER
L18   VCCAUX   POWER
L22   VCCAUX   POWER
L5   VCCAUX   POWER
M17   VCCAUX   POWER
N10   VCCAUX   POWER
R22   VCCAUX   POWER
U12   VCCAUX   POWER
U14   VCCAUX   POWER
U18   VCCAUX   POWER
U6   VCCAUX   POWER
V17   VCCAUX   POWER
V9   VCCAUX   POWER
W13   VCCAUX   POWER
K11   VCCINT   POWER
K17   VCCINT   POWER
L12   VCCINT   POWER
L14   VCCINT   POWER
L16   VCCINT   POWER
M11   VCCINT   POWER
M12   VCCINT   POWER
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[Diff Pin]   inv_Pin   vdiff   tdelay_typ   tdelay_min   tdelay_max
R9   P8   100mV   0   0   0
| FMC0_ZDOK_P<0>   BLVDS_25_LR_25   BLVDS_25
N5   N4   100mV   0   0   0
| FMC0_ZDOK_P<1>   BLVDS_25_LR_25   BLVDS_25
AA7   AA6   100mV   0   0   0
| FMC0_ZDOK_P<2>   BLVDS_25_TB_25   BLVDS_25
AD4   AF4   100mV   0   0   0
| FMC0_ZDOK_P<3>   BLVDS_25_TB_25   BLVDS_25
B22   A22   100mV   0   0   0
| FMC1_ZDOK_P<0>   BLVDS_25_TB_25   BLVDS_25
G19   F19   100mV   0   0   0
| FMC1_ZDOK_P<1>   BLVDS_25_TB_25   BLVDS_25
B23   A23   100mV   0   0   0
| FMC1_ZDOK_P<2>   BLVDS_25_TB_25   BLVDS_25
D21   D22   100mV   0   0   0
| FMC1_ZDOK_P<3>   BLVDS_25_TB_25   BLVDS_25
F24   F26   100mv   0   0   0
| mcb5_dram_dqs   D_SSTL15_II_LR_25   SSTL15_II_LR_25
L2   L1   100mv   0   0   0
| mcb4_dram_udqs   D_SSTL15_II_LR_25   SSTL15_II_LR_25
M24   M26   100mv   0   0   0
| mcb5_dram_udqs   D_SSTL15_II_LR_25   SSTL15_II_LR_25
F3   F1   100mv   0   0   0
| mcb4_dram_dqs   D_SSTL15_II_LR_25   SSTL15_II_LR_25
K5   J5   100mv   0   0   0
| mcb4_dram_ck   D_SSTL15_II_LR_25   SSTL15_II_LR_25
B25   B26   100mv   0   0   0
| mcb5_dram_ck   D_SSTL15_II_LR_25   SSTL15_II_LR_25
E13   D13   100mv   0   0   0
| FMC1_LA_P<0>   LVDS_25_TB_25   LVDS_25
C13   A13   100mv   0   0   0
| FMC1_LA_P<1>   LVDS_25_TB_25   LVDS_25
H8   G8   100mv   0   0   0
| FMC1_LA_P<2>   LVDS_25_TB_25   LVDS_25
F7   F6   100mv   0   0   0
| FMC1_LA_P<3>   LVDS_25_TB_25   LVDS_25
C3   B3   100mv   0   0   0
| FMC1_LA_P<4>   LVDS_25_TB_25   LVDS_25
G6   F5   100mv   0   0   0
| FMC1_LA_P<5>   LVDS_25_TB_25   LVDS_25
E6   E5   100mv   0   0   0
| FMC1_LA_P<6>   LVDS_25_TB_25   LVDS_25
H9   G9   100mv   0   0   0
| FMC1_LA_P<7>   LVDS_25_TB_25   LVDS_25
A3   A2   100mv   0   0   0
| FMC1_LA_P<8>   LVDS_25_TB_25   LVDS_25
F9   E8   100mv   0   0   0
| FMC1_LA_P<9>   LVDS_25_TB_25   LVDS_25
D5   C5   100mv   0   0   0
| FMC1_LA_P<10>   LVDS_25_TB_25   LVDS_25
H10   G10   100mv   0   0   0
| FMC1_LA_P<11>   LVDS_25_TB_25   LVDS_25
B4   A4   100mv   0   0   0
| FMC1_LA_P<12>   LVDS_25_TB_25   LVDS_25
K12   J12   100mv   0   0   0
| FMC1_LA_P<20>   LVDS_25_TB_25   LVDS_25
F10   E10   100mv   0   0   0
| FMC1_LA_P<13>   LVDS_25_TB_25   LVDS_25
J13   H13   100mv   0   0   0
| FMC1_LA_P<21>   LVDS_25_TB_25   LVDS_25
B5   A5   100mv   0   0   0
| FMC1_LA_P<14>   LVDS_25_TB_25   LVDS_25
F14   E14   100mv   0   0   0
| FMC1_LA_P<22>   LVDS_25_TB_25   LVDS_25
F20   E20   100mv   0   0   0
| FMC1_LA_P<30>   LVDS_25_TB_25   LVDS_25
G12   F11   100mv   0   0   0
| FMC1_LA_P<15>   LVDS_25_TB_25   LVDS_25
K14   H14   100mv   0   0   0
| FMC1_LA_P<23>   LVDS_25_TB_25   LVDS_25
H17   G17   100mv   0   0   0
| FMC1_LA_P<31>   LVDS_25_TB_25   LVDS_25
F12   E12   100mv   0   0   0
| FMC1_LA_P<16>   LVDS_25_TB_25   LVDS_25
J15   H15   100mv   0   0   0
| FMC1_LA_P<24>   LVDS_25_TB_25   LVDS_25
C21   B21   100mv   0   0   0
| FMC1_LA_P<32>   LVDS_25_TB_25   LVDS_25
B12   A12   100mv   0   0   0
| FMC1_LA_P<17>   LVDS_25_TB_25   LVDS_25
J16   J17   100mv   0   0   0
| FMC1_LA_P<25>   LVDS_25_TB_25   LVDS_25
H18   H19   100mv   0   0   0
| FMC1_LA_P<33>   LVDS_25_TB_25   LVDS_25
J11   G11   100mv   0   0   0
| FMC1_LA_P<18>   LVDS_25_TB_25   LVDS_25
F16   E16   100mv   0   0   0
| FMC1_LA_P<26>   LVDS_25_TB_25   LVDS_25
H12   G13   100mv   0   0   0
| FMC1_LA_P<19>   LVDS_25_TB_25   LVDS_25
G15   F15   100mv   0   0   0
| FMC1_LA_P<27>   LVDS_25_TB_25   LVDS_25
F18   E18   100mv   0   0   0
| FMC1_LA_P<28>   LVDS_25_TB_25   LVDS_25
G16   F17   100mv   0   0   0
| FMC1_LA_P<29>   LVDS_25_TB_25   LVDS_25
AA19   AB19   100mv   0   0   0
| FMC0_LA_P<10>   LVDS_25_TB_25   LVDS_25
W16   Y16   100mv   0   0   0
| FMC0_LA_P<11>   LVDS_25_TB_25   LVDS_25
AA18   AB17   100mv   0   0   0
| FMC0_LA_P<12>   LVDS_25_TB_25   LVDS_25
W14   Y13   100mv   0   0   0
| FMC0_LA_P<20>   LVDS_25_TB_25   LVDS_25
Y15   AA16   100mv   0   0   0
| FMC0_LA_P<13>   LVDS_25_TB_25   LVDS_25
V12   W12   100mv   0   0   0
| FMC0_LA_P<21>   LVDS_25_TB_25   LVDS_25
V14   V15   100mv   0   0   0
| FMC0_LA_P<14>   LVDS_25_TB_25   LVDS_25
AB13   AA13   100mv   0   0   0
| FMC0_LA_P<22>   LVDS_25_TB_25   LVDS_25
Y9   AA8   100mv   0   0   0
| FMC0_LA_P<30>   LVDS_25_TB_25   LVDS_25
U13   V13   100mv   0   0   0
| FMC0_LA_P<15>   LVDS_25_TB_25   LVDS_25
Y11   AA11   100mv   0   0   0
| FMC0_LA_P<23>   LVDS_25_TB_25   LVDS_25
AB7   AC6   100mv   0   0   0
| FMC0_LA_P<31>   LVDS_25_TB_25   LVDS_25
AA15   AB15   100mv   0   0   0
| FMC0_LA_P<16>   LVDS_25_TB_25   LVDS_25
V11   V10   100mv   0   0   0
| FMC0_LA_P<24>   LVDS_25_TB_25   LVDS_25
AC5   AD5   100mv   0   0   0
| FMC0_LA_P<32>   LVDS_25_TB_25   LVDS_25
AE13   AF13   100mv   0   0   0
| FMC0_LA_P<17>   LVDS_25_TB_25   LVDS_25
AA9   AB9   100mv   0   0   0
| FMC0_LA_P<25>   LVDS_25_TB_25   LVDS_25
W8   W7   100mv   0   0   0
| FMC0_LA_P<33>   LVDS_25_TB_25   LVDS_25
AD14   AF14   100mv   0   0   0
| FMC0_LA_P<18>   LVDS_25_TB_25   LVDS_25
AA10   AB11   100mv   0   0   0
| FMC0_LA_P<26>   LVDS_25_TB_25   LVDS_25
Y12   AA12   100mv   0   0   0
| FMC0_LA_P<19>   LVDS_25_TB_25   LVDS_25
AD6   AF6   100mv   0   0   0
| FMC0_LA_P<27>   LVDS_25_TB_25   LVDS_25
W10   W9   100mv   0   0   0
| FMC0_LA_P<28>   LVDS_25_TB_25   LVDS_25
AE5   AF5   100mv   0   0   0
| FMC0_LA_P<29>   LVDS_25_TB_25   LVDS_25
AE15   AF15   100mv   0   0   0
| FMC0_LA_P<0>   LVDS_25_TB_25   LVDS_25
AB14   AC14   100mv   0   0   0
| FMC0_LA_P<1>   LVDS_25_TB_25   LVDS_25
Y21   AA22   100mv   0   0   0
| FMC0_LA_P<2>   LVDS_25_TB_25   LVDS_25
W20   Y20   100mv   0   0   0
| FMC0_LA_P<3>   LVDS_25_TB_25   LVDS_25
AB22   AC22   100mv   0   0   0
| FMC0_LA_P<4>   LVDS_25_TB_25   LVDS_25
V18   W19   100mv   0   0   0
| FMC0_LA_P<5>   LVDS_25_TB_25   LVDS_25
W17   W18   100mv   0   0   0
| FMC0_LA_P<6>   LVDS_25_TB_25   LVDS_25
AA21   AB21   100mv   0   0   0
| FMC0_LA_P<7>   LVDS_25_TB_25   LVDS_25
Y17   AA17   100mv   0   0   0
| FMC0_LA_P<8>   LVDS_25_TB_25   LVDS_25
U15   V16   100mv   0   0   0
| FMC0_LA_P<9>   LVDS_25_TB_25   LVDS_25
[Series Pin Mapping] pin_2   model_name   function_table_group
AA7   AA6   rterm25_100_25
| FMC0_ZDOK_P<2>   BLVDS_25_TB_25   BLVDS_25
AD4   AF4   rterm25_100_25
| FMC0_ZDOK_P<3>   BLVDS_25_TB_25   BLVDS_25
B22   A22   rterm25_100_25
| FMC1_ZDOK_P<0>   BLVDS_25_TB_25   BLVDS_25
G19   F19   rterm25_100_25
| FMC1_ZDOK_P<1>   BLVDS_25_TB_25   BLVDS_25
B23   A23   rterm25_100_25
| FMC1_ZDOK_P<2>   BLVDS_25_TB_25   BLVDS_25
D21   D22   rterm25_100_25
| FMC1_ZDOK_P<3>   BLVDS_25_TB_25   BLVDS_25
AA19   AB19   rterm25_100_25
| FMC0_LA_P<10>   LVDS_25_TB_25   LVDS_25
W16   Y16   rterm25_100_25
| FMC0_LA_P<11>   LVDS_25_TB_25   LVDS_25
AA18   AB17   rterm25_100_25
| FMC0_LA_P<12>   LVDS_25_TB_25   LVDS_25
W14   Y13   rterm25_100_25
| FMC0_LA_P<20>   LVDS_25_TB_25   LVDS_25
Y15   AA16   rterm25_100_25
| FMC0_LA_P<13>   LVDS_25_TB_25   LVDS_25
V12   W12   rterm25_100_25
| FMC0_LA_P<21>   LVDS_25_TB_25   LVDS_25
V14   V15   rterm25_100_25
| FMC0_LA_P<14>   LVDS_25_TB_25   LVDS_25
AB13   AA13   rterm25_100_25
| FMC0_LA_P<22>   LVDS_25_TB_25   LVDS_25
Y9   AA8   rterm25_100_25
| FMC0_LA_P<30>   LVDS_25_TB_25   LVDS_25
U13   V13   rterm25_100_25
| FMC0_LA_P<15>   LVDS_25_TB_25   LVDS_25
Y11   AA11   rterm25_100_25
| FMC0_LA_P<23>   LVDS_25_TB_25   LVDS_25
AB7   AC6   rterm25_100_25
| FMC0_LA_P<31>   LVDS_25_TB_25   LVDS_25
AA15   AB15   rterm25_100_25
| FMC0_LA_P<16>   LVDS_25_TB_25   LVDS_25
V11   V10   rterm25_100_25
| FMC0_LA_P<24>   LVDS_25_TB_25   LVDS_25
AC5   AD5   rterm25_100_25
| FMC0_LA_P<32>   LVDS_25_TB_25   LVDS_25
AE13   AF13   rterm25_100_25
| FMC0_LA_P<17>   LVDS_25_TB_25   LVDS_25
AA9   AB9   rterm25_100_25
| FMC0_LA_P<25>   LVDS_25_TB_25   LVDS_25
W8   W7   rterm25_100_25
| FMC0_LA_P<33>   LVDS_25_TB_25   LVDS_25
AD14   AF14   rterm25_100_25
| FMC0_LA_P<18>   LVDS_25_TB_25   LVDS_25
AA10   AB11   rterm25_100_25
| FMC0_LA_P<26>   LVDS_25_TB_25   LVDS_25
Y12   AA12   rterm25_100_25
| FMC0_LA_P<19>   LVDS_25_TB_25   LVDS_25
AD6   AF6   rterm25_100_25
| FMC0_LA_P<27>   LVDS_25_TB_25   LVDS_25
W10   W9   rterm25_100_25
| FMC0_LA_P<28>   LVDS_25_TB_25   LVDS_25
AE5   AF5   rterm25_100_25
| FMC0_LA_P<29>   LVDS_25_TB_25   LVDS_25
AE15   AF15   rterm25_100_25
| FMC0_LA_P<0>   LVDS_25_TB_25   LVDS_25
AB14   AC14   rterm25_100_25
| FMC0_LA_P<1>   LVDS_25_TB_25   LVDS_25
Y21   AA22   rterm25_100_25
| FMC0_LA_P<2>   LVDS_25_TB_25   LVDS_25
W20   Y20   rterm25_100_25
| FMC0_LA_P<3>   LVDS_25_TB_25   LVDS_25
AB22   AC22   rterm25_100_25
| FMC0_LA_P<4>   LVDS_25_TB_25   LVDS_25
V18   W19   rterm25_100_25
| FMC0_LA_P<5>   LVDS_25_TB_25   LVDS_25
W17   W18   rterm25_100_25
| FMC0_LA_P<6>   LVDS_25_TB_25   LVDS_25
AA21   AB21   rterm25_100_25
| FMC0_LA_P<7>   LVDS_25_TB_25   LVDS_25
Y17   AA17   rterm25_100_25
| FMC0_LA_P<8>   LVDS_25_TB_25   LVDS_25
U15   V16   rterm25_100_25
| FMC0_LA_P<9>   LVDS_25_TB_25   LVDS_25
E13   D13   rterm25_100_25
| FMC1_LA_P<0>   LVDS_25_TB_25   LVDS_25
C13   A13   rterm25_100_25
| FMC1_LA_P<1>   LVDS_25_TB_25   LVDS_25
H8   G8   rterm25_100_25
| FMC1_LA_P<2>   LVDS_25_TB_25   LVDS_25
F7   F6   rterm25_100_25
| FMC1_LA_P<3>   LVDS_25_TB_25   LVDS_25
C3   B3   rterm25_100_25
| FMC1_LA_P<4>   LVDS_25_TB_25   LVDS_25
G6   F5   rterm25_100_25
| FMC1_LA_P<5>   LVDS_25_TB_25   LVDS_25
E6   E5   rterm25_100_25
| FMC1_LA_P<6>   LVDS_25_TB_25   LVDS_25
H9   G9   rterm25_100_25
| FMC1_LA_P<7>   LVDS_25_TB_25   LVDS_25
A3   A2   rterm25_100_25
| FMC1_LA_P<8>   LVDS_25_TB_25   LVDS_25
F9   E8   rterm25_100_25
| FMC1_LA_P<9>   LVDS_25_TB_25   LVDS_25
D5   C5   rterm25_100_25
| FMC1_LA_P<10>   LVDS_25_TB_25   LVDS_25
H10   G10   rterm25_100_25
| FMC1_LA_P<11>   LVDS_25_TB_25   LVDS_25
B4   A4   rterm25_100_25
| FMC1_LA_P<12>   LVDS_25_TB_25   LVDS_25
K12   J12   rterm25_100_25
| FMC1_LA_P<20>   LVDS_25_TB_25   LVDS_25
F10   E10   rterm25_100_25
| FMC1_LA_P<13>   LVDS_25_TB_25   LVDS_25
J13   H13   rterm25_100_25
| FMC1_LA_P<21>   LVDS_25_TB_25   LVDS_25
B5   A5   rterm25_100_25
| FMC1_LA_P<14>   LVDS_25_TB_25   LVDS_25
F14   E14   rterm25_100_25
| FMC1_LA_P<22>   LVDS_25_TB_25   LVDS_25
F20   E20   rterm25_100_25
| FMC1_LA_P<30>   LVDS_25_TB_25   LVDS_25
G12   F11   rterm25_100_25
| FMC1_LA_P<15>   LVDS_25_TB_25   LVDS_25
K14   H14   rterm25_100_25
| FMC1_LA_P<23>   LVDS_25_TB_25   LVDS_25
H17   G17   rterm25_100_25
| FMC1_LA_P<31>   LVDS_25_TB_25   LVDS_25
F12   E12   rterm25_100_25
| FMC1_LA_P<16>   LVDS_25_TB_25   LVDS_25
J15   H15   rterm25_100_25
| FMC1_LA_P<24>   LVDS_25_TB_25   LVDS_25
C21   B21   rterm25_100_25
| FMC1_LA_P<32>   LVDS_25_TB_25   LVDS_25
B12   A12   rterm25_100_25
| FMC1_LA_P<17>   LVDS_25_TB_25   LVDS_25
J16   J17   rterm25_100_25
| FMC1_LA_P<25>   LVDS_25_TB_25   LVDS_25
H18   H19   rterm25_100_25
| FMC1_LA_P<33>   LVDS_25_TB_25   LVDS_25
J11   G11   rterm25_100_25
| FMC1_LA_P<18>   LVDS_25_TB_25   LVDS_25
F16   E16   rterm25_100_25
| FMC1_LA_P<26>   LVDS_25_TB_25   LVDS_25
H12   G13   rterm25_100_25
| FMC1_LA_P<19>   LVDS_25_TB_25   LVDS_25
G15   F15   rterm25_100_25
| FMC1_LA_P<27>   LVDS_25_TB_25   LVDS_25
F18   E18   rterm25_100_25
| FMC1_LA_P<28>   LVDS_25_TB_25   LVDS_25
G16   F17   rterm25_100_25
| FMC1_LA_P<29>   LVDS_25_TB_25   LVDS_25
|   100ohm differential resistor
[Model]   rterm25_100_25
Model_type   Series
|   (typ)   (min)   (max)
C_comp   0.0000pF   0.0000pF   0.0000pF
[Temperature Range]   25.0000   85.0000   0.000
[Voltage Range]   2.5000V   2.3V   2.7V
[R Series]   100   175   80
| Models and submodels in the file (12): rterm25_100_25 (Series), BLVDS_25_LR_25 (I/O), BLVDS_25_TB_25 (I/O), LVCMOS25_F_12_LR_25 (I/O), LVCMOS25_F_12_TB_25 (I/O), LVCMOS25_S_8_TB_25 (I/O), LVCMOS25_S_12_LR_25 (I/O), LVCMOS25_S_12_TB_25 (I/O), LVCMOS25_S_24_LR_25 (I/O), LVCMOS33_S_12_LR_25 (I/O), LVDS_25_TB_25 (I/O), SSTL15_II_LR_25 (I/O)

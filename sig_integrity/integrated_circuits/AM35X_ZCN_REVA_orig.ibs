| IBIS file generated by GenIBIS.pl Version 3.07
|   am35xxzcn
[IBIS ver]   3.2
[File name]   AM35X_ZCN_REVA.ibs
[File Rev]   1.0
[Date]   Mon May 10, 2010, 10:46:0
[Source]   Data created at Texas Instruments
[Notes]   1) IBIS spec conformance checker (IBISCK4) ran with 0 errors
   and 179 warnings.  Warnings can be waived.
[Disclaimer] Please be aware that in the absence of a written agreement,
                Texas Instruments (TI) assumes no liability for: 1) the
                accuracy of the IBIS models provided to your company, 2) the
                proper functioning of these IBIS models in your design or for
                any resulting applications, or, 3) infringement of patents,
                copyrights, or intellectual property rights resulting from
                your use of these IBIS models. TI provides IBIS models as a
                service to our customers and therefore reserves the right to
                limit distribution of the IBIS models.
[Copyright]   Property of Texas Instruments Incorporated. Unauthorised
   reproduction and/or distribution is strictly prohibited. This
   product is protected under copyright law and trade secret law
   as an unpublished work. Created 2010,(C) Copyright 2010,
   Texas Instruments Incorporated., All Rights Reserved. These
   commodities are under the U.S. Government distribution license
   control.As such,they are not to be re-exported without the
   prior approval of the U.S. Department of Commerce.
|   Component am35xxzcn
[Component]   am35xxzcn
[Manufacturer]   Texas Instruments.
[Package Model] am35xxzcn
[Package]
|   typ   min   max
R_pkg   0.6975   3.15E-1   1.08E0
L_pkg   3.5033E-009   2.66E-11   6.98E-9
C_pkg   6.86115E-013   2.23E-15   1.37E-12
[Pin]   signal_name   model_name
A2   SDRC_DQS3P   Selector_16
A3   SDRC_D25   Selector_16
A4   SDRC_STRBEN_DLY1   Selector_16
A5   SDRC_STRBEN1   Selector_3
A6   SDRC_DQS2P   Selector_16
A7   SDRC_D16   Selector_16
A8   SDRC_A12   Selector_27
A9   SDRC_A10   Selector_27
A10   SDRC_A5   Selector_27
A11   SDRC_A0   Selector_27
A12   SDRC_BA0   Selector_27
A13   SDRC_CLK   Selector_27
A14   SDRC_NCS1   Selector_27
A15   SDRC_D15   Selector_16
A16   SDRC_D14   Selector_16
A17   SDRC_DQS1N   Selector_16
A18   SDRC_STRBEN_DLY0   Selector_16
A19   SDRC_STRBEN0   Selector_3
A20   SDRC_DQS0N   Selector_16
A21   SDRC_D1   Selector_16
A22   MCBSP4_FSX   Selector_25
A23   MCBSP4_DR   Selector_25
A24   MCBSP3_CLKX   Selector_25
AA1   SYS_BOOT1   Selector_26
AA2   SYS_BOOT2   Selector_26
AA3   SYS_BOOT3   Selector_26
AA7   RMII_RXD1   Selector_12
AA9   MMC1_CLK   Selector_25
AA10   MMC1_DAT3   Selector_25
AA16   MCSPI2_CS0   Selector_4
AA18   ETK_D3   Selector_8
AA19   UART1_TX   Selector_25
AA23   DSS_DATA7   Selector_8
AA24   DSS_DATA8   Selector_8
AA25   DSS_DATA9   Selector_8
AB1   SYS_BOOT4   Selector_26
AB2   SYS_BOOT5   Selector_26
AB6   CCDC_DATA6   Selector_25
AB7   RMII_CRS_DV   Selector_12
AB9   MMC1_CMD   Selector_25
AB10   MMC1_DAT4   Selector_25
AB12   MMC2_DAT0   Selector_12
AB13   MMC2_DAT4   Selector_25
AB15   MCSPI1_CS0   Selector_12
AB16   MCSPI2_SOMI   Selector_8
AB18   ETK_D2   Selector_4
AB19   ETK_D7   Selector_8
AB20   ETK_D11   Selector_8
AB24   DSS_DATA5   Selector_25
AB25   DSS_DATA6   Selector_8
AC1   SYS_BOOT6   Selector_26
AC2   SYS_BOOT7   Selector_23
AC3   SYS_BOOT8   Selector_23
AC5   CCDC_DATA2   Selector_25
AC6   CCDC_DATA7   Selector_25
AC7   RMII_RXER   Selector_12
AC9   MMC1_DAT0   Selector_25
AC10   MMC1_DAT5   Selector_25
AC12   MMC2_DAT1   Selector_12
AC13   MMC2_DAT5   Selector_25
AC15   MCSPI1_SOMI   Selector_25
AC16   MCSPI2_SIMO   Selector_8
AC18   ETK_D1   Selector_4
AC20   ETK_D10   Selector_8
AC21   ETK_D14   Selector_25
AC23   DSS_DATA2   Selector_25
AC24   DSS_DATA3   Selector_25
AC25   DSS_DATA4   Selector_25
AD1   CCDC_FIELD   Selector_25
AD2   CCDC_PCLK   Selector_25
AD3   CCDC_VD   Selector_25
AD4   CCDC_DATA0   Selector_25
AD5   CCDC_DATA3   Selector_25
AD6   RMII_MDIO_CLK   Selector_12
AD7   RMII_TXD0   Selector_12
AD8   RMII_TXEN   Selector_12
AD9   MMC1_DAT1   Selector_25
AD10   MMC1_DAT6   Selector_25
AD11   MMC2_CLK   Selector_25
AD12   MMC2_DAT2   Selector_12
AD13   MMC2_DAT6   Selector_25
AD14   MCSPI1_CS1   Selector_12
AD15   MCSPI1_SIMO   Selector_25
AD16   MCSPI2_CLK   Selector_8
AD17   ETK_CLK   Selector_4
AD18   ETK_D0   Selector_4
AD19   ETK_D6   Selector_8
AD20   ETK_D9   Selector_8
AD21   ETK_D13   Selector_25
AD22   DSS_HSYNC   Selector_12
AD23   DSS_VSYNC   Selector_12
AD24   DSS_DATA0   Selector_25
AD25   DSS_DATA1   Selector_25
AE2   CCDC_HD   Selector_25
AE3   CCDC_WEN   Selector_25
AE4   CCDC_DATA1   Selector_25
AE5   CCDC_DATA4   Selector_25
AE6   RMII_MDIO_DATA   Selector_12
AE7   RMII_TXD1   Selector_12
AE8   RMII_50MHZ_CLK   Selector_12
AE9   MMC1_DAT2   Selector_25
AE10   MMC1_DAT7   Selector_25
AE11   MMC2_CMD   Selector_12
AE12   MMC2_DAT3   Selector_12
AE13   MMC2_DAT7   Selector_25
AE14   MCSPI1_CLK   Selector_25
AE15   MCSPI1_CS2   Selector_4
AE16   MCSPI1_CS3   Selector_4
AE17   MCSPI2_CS1   Selector_8
AE18   ETK_CTL   Selector_4
AE19   ETK_D5   Selector_8
AE20   ETK_D8   Selector_8
AE21   ETK_D12   Selector_25
AE22   ETK_D15   Selector_25
AE23   DSS_PCLK   Selector_12
AE24   DSS_ACBIAS   Selector_25
B1   SDRC_D30   Selector_16
B2   SDRC_DQS3N   Selector_16
B3   SDRC_D26   Selector_16
B4   SDRC_D24   Selector_16
B5   SDRC_D22   Selector_16
B6   SDRC_DQS2N   Selector_16
B7   SDRC_D17   Selector_16
B8   SDRC_A13   Selector_27
B9   SDRC_A11   Selector_27
B10   SDRC_A6   Selector_27
B11   SDRC_A1   Selector_27
B13   SDRC_NCLK   Selector_27
B14   SDRC_NWE   Selector_27
B15   SDRC_DM1   Selector_27
B16   SDRC_D13   Selector_16
B17   SDRC_DQS1P   Selector_16
B18   SDRC_D8   Selector_16
B19   SDRC_D7   Selector_16
B20   SDRC_DQS0P   Selector_16
B21   SDRC_D0   Selector_16
B22   MCBSP4_DX   Selector_25
B23   MCBSP4_CLKX   Selector_25
B24   MCBSP3_DX   Selector_25
B25   MCBSP2_DR   Selector_25
C1   SDRC_D31   Selector_16
C2   SDRC_D28   Selector_16
C3   SDRC_D27   Selector_16
C5   SDRC_D23   Selector_16
C6   SDRC_D20   Selector_16
C8   SDRC_ODT0   Selector_3
C10   SDRC_A7   Selector_27
C11   SDRC_A2   Selector_27
C13   SDRC_BA1   Selector_27
C14   SDRC_NRAS   Selector_27
C16   SDRC_D12   Selector_16
C17   SDRC_D10   Selector_16
C19   SDRC_D6   Selector_16
C20   SDRC_D3   Selector_16
C21   SDRC_DM0   Selector_27
C23   MCBSP3_FSX   Selector_25
C24   MCBSP3_DR   Selector_25
C25   MCBSP2_CLKX   Selector_25
D1   SDRC_DM3   Selector_27
D2   SDRC_D29   Selector_16
D6   SDRC_D21   Selector_16
D7   SDRC_D18   Selector_16
D8   SDRC_A14   Selector_27
D10   SDRC_A8   Selector_27
D11   SDRC_A3   Selector_27
D13   SDRC_BA2   Selector_27
D14   SDRC_CKE0   Selector_27
D16   SDRC_D11   Selector_16
D17   SDRC_D9   Selector_16
D19   SDRC_D5   Selector_16
D20   SDRC_D2   Selector_16
D24   MCBSP2_DX   Selector_25
D25   MCBSP2_FSX   Selector_25
E1   GPMC_A3   Selector_1
E2   GPMC_A2   Selector_1
E3   GPMC_A1   Selector_1
E7   SDRC_D19   Selector_16
E8   SDRC_DM2   Selector_27
E10   SDRC_A9   Selector_27
E11   SDRC_A4   Selector_27
E13   SDRC_NCS0   Selector_27
E14   SDRC_NCAS   Selector_27
E19   SDRC_D4   Selector_16
E23   UART2_RX   Selector_12
E24   UART2_TX   Selector_12
E25   USB0_DRVVBUS   Selector_9
F1   GPMC_A9   Selector_28
F2   GPMC_A8   Selector_28
F3   GPMC_A7   Selector_28
F4   GPMC_A6   Selector_28
F6   GPMC_A5   Selector_1
F7   GPMC_A4   Selector_1
F19   UART2_RTS   Selector_12
F20   UART2_CTS   Selector_12
G1   GPMC_D4   Selector_28
G2   GPMC_D3   Selector_28
G3   GPMC_D2   Selector_28
G4   GPMC_D1   Selector_28
G5   GPMC_D0   Selector_28
G6   GPMC_A10   Selector_28
H1   GPMC_D6   Selector_28
H2   GPMC_D5   Selector_28
J1   GPMC_D11   Selector_28
J2   GPMC_D10   Selector_28
J3   GPMC_D9   Selector_28
J4   GPMC_D8   Selector_28
J5   GPMC_D7   Selector_28
K1   GPMC_D15   Selector_28
K2   GPMC_D14   Selector_28
K3   GPMC_D13   Selector_28
K4   GPMC_D12   Selector_28
K24   SYS_32K   Selector_17
K25   SYS_XTALIN   Selector_11
L1   GPMC_NCS1   Selector_28
L2   GPMC_NCS0   Selector_28
L25   HDQ_SIO   Selector_14
M1   GPMC_NCS5   Selector_28
M2   GPMC_NCS4   Selector_28
M3   GPMC_NCS3   Selector_28
M4   GPMC_NCS2   Selector_28
M24   SYS_CLKREQ   Selector_5
M25   SYS_CLKOUT2   Selector_5
N1   GPMC_CLK   Selector_6
N2   UART3_CTS_RCTX   Selector_14
N3   UART3_RTS_SD   Selector_18
N4   GPMC_NCS7   Selector_28
N5   GPMC_NCS6   Selector_28
N24   MCBSP1_CLKX   Selector_8
N25   SYS_CLKOUT1   Selector_14
P1   UART3_RX_IRRX   Selector_18
P2   UART3_TX_IRTX   Selector_18
P21   MCBSP1_FSR   Selector_8
P22   MCBSP1_DX   Selector_8
P23   MCBSP1_DR   Selector_8
P24   MCBSP1_FSX   Selector_8
P25   MCBSP_CLKS   Selector_8
R1   GPMC_NADV_ALE   Selector_20
R2   GPMC_NOE   Selector_21
R3   GPMC_NWE   Selector_21
R4   GPMC_NBE0_CLE   Selector_1
R24   JTAG_EMU1   Selector_14
R25   MCBSP1_CLKR   Selector_8
T1   GPMC_NBE1   Selector_1
T2   GPMC_NWP   Selector_1
T3   GPMC_WAIT0   Selector_22
T4   GPMC_WAIT1   Selector_19
T5   GPMC_WAIT2   Selector_19
T21   JTAG_RTCK   Selector_2
T22   JTAG_TMS_TMSC   Selector_14
T23   JTAG_TDI   Selector_15
T24   JTAG_TDO   Selector_2
T25   JTAG_EMU0   Selector_14
U1   GPMC_WAIT3   Selector_19
U21   DSS_DATA21   Selector_8
U22   DSS_DATA22   Selector_8
U23   DSS_DATA23   Selector_8
U24   JTAG_NTRST   Selector_13
U25   JTAG_TCK   Selector_13
V2   HECC1_TXD   Selector_18
V3   HECC1_RXD   Selector_18
V4   I2C1_SCL   Selector_7
V5   I2C1_SDA   Selector_7
V24   DSS_DATA19   Selector_8
V25   DSS_DATA20   Selector_8
W1   I2C2_SCL   Selector_10
W2   I2C2_SDA   Selector_10
W4   I2C3_SCL   Selector_10
W5   I2C3_SDA   Selector_10
W20   UART1_RX   Selector_25
W21   DSS_DATA14   Selector_8
W22   DSS_DATA15   Selector_8
W23   DSS_DATA16   Selector_8
W24   DSS_DATA17   Selector_8
W25   DSS_DATA18   Selector_8
Y1   SYS_NIRQ   Selector_18
Y2   SYS_NRESPWRON   Selector_24
Y3   SYS_NRESWARM   Selector_9
Y4   SYS_BOOT0   Selector_26
Y6   CCDC_DATA5   Selector_25
Y7   RMII_RXD0   Selector_12
Y18   ETK_D4   Selector_8
Y19   UART1_RTS   Selector_25
Y20   UART1_CTS   Selector_25
Y22   DSS_DATA10   Selector_8
Y23   DSS_DATA11   Selector_8
Y24   DSS_DATA12   Selector_8
Y25   DSS_DATA13   Selector_8
| Device pads which are not required to be modeled. Included for completeness
|A1   VSS   VSS.PAD
|A25   VSS   VSS.PAD
|AA12   CAP_VDD_SRAM_MPU   PASSIVE.PAD
|AA13   VDDS_SRAM_MPU   VDD.PAD
|AA15   VDDS_DPLL_MPU_USBHOST VDD.PAD
|AE1   VSS   VSS.PAD
|AE25   VSS   VSS.PAD
|B12   DDR_PADREF   OVTPOSSTL18TCG_7LM.PAD
|E16   CAP_VDD_SRAM_CORE   PASSIVE.PAD
|E17   VDDS_SRAM_CORE_BG   VDD.PAD
|F8   VDDS   VDD.PAD
|F10   VDDS   VDD.PAD
|F11   VDDS   VDD.PAD
|F13   VDDS   VDD.PAD
|F14   VREFSSTL   PASSIVE.PAD
|F16   VDDS   VDD.PAD
|F22   CAP_VDDA1P2LDO_USBPHY PASSIVE.PAD
|F23   VDDA3P3V_USBPHY   VDD.PAD
|F24   USB0_DM   COMPLEXIO.PAD
|F25   USB0_DP   COMPLEXIO.PAD
|G8   VDDS   VDD.PAD
|G10   VDDS   VDD.PAD
|G11   VDDS   VDD.PAD
|G13   VDDS   VDD.PAD
|G14   VDDS   VDD.PAD
|G16   VDDS   VDD.PAD
|G17   VDDS   VDD.PAD
|G20   VSS   VSS.PAD
|G21   VSS   VSS.PAD
|G22   VDDA1P8V_USBPHY   VDD.PAD
|G24   USB0_VBUS   COMPLEXIO.PAD
|G25   USB0_ID   COMPLEXIO.PAD
|H8   VDDS   VDD.PAD
|H9   VSS   VSS.PAD
|H10   VDD_CORE   VDD.PAD
|H11   VDD_CORE   VDD.PAD
|H12   VSS   VSS.PAD
|H13   VSS   VSS.PAD
|H14   VSS   VSS.PAD
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[Model Selector] Selector_1
Model_56 I/O,1.8V,PD
Model_57 I/O,1.8V,PU
Model_58 I/O,1.8V,PI
Model_59 I/O,3.3V,PD
Model_60 I/O,3.3V,PU
Model_61 I/O,3.3V,PI
|   Usage O#1.8V/3.3V###BC1833DV50BTPBFZP18LL_7LM.PAD
|   Base model BC1833DV50BTPBFZP18LL_7LM
[Model Selector] Selector_2
Model_10 I/O,3.3V,PD
Model_11 I/O,3.3V,PU
Model_12 I/O,3.3V,PI
Model_7 I/O,1.8V,PD
Model_8 I/O,1.8V,PU
Model_9 I/O,1.8V,PI
|   Usage IO#1.8V#NONE_LVCMOS#FAST#BSSTL18TCSCGPBFZ_7LM.PAD
|   Base model BSSTL18TCSCGPBFZ_7LM
[Model Selector] Selector_3
Model_102 3-STATE,1.8V,PI,FAST,+-10%V
Model_105 INPUT,1.8V,NONE_LVCMOS,+-10%V
Model_115 3-STATE,1.8V,PI,FAST,+-0.1V
Model_118 INPUT,1.8V,NONE_LVCMOS,+-0.1V
|   Usage IO#1.8V/3.3V#PD/PI/PU##BC1833DV40CTPBFHP18LL_7LM.PAD
|   Base model BC1833DV40CTPBFHP18LL_7LM
[Model Selector] Selector_4
Model_1 I/O,1.8V,PD
Model_2 I/O,1.8V,PU
Model_3 I/O,1.8V,PI
Model_4 I/O,3.3V,PD
Model_5 I/O,3.3V,PU
Model_6 I/O,3.3V,PI
|   Usage IO#1.8V/3.3V#PD/PI/PU##BC1833DV50BTPBFZP18LL_7LM.PAD
|   Base model BC1833DV50BTPBFZP18LL_7LM
[Model Selector] Selector_5
Model_10 I/O,3.3V,PD
Model_11 I/O,3.3V,PU
Model_12 I/O,3.3V,PI
Model_7 I/O,1.8V,PD
Model_8 I/O,1.8V,PU
Model_9 I/O,1.8V,PI
|   Usage IO#1.8V/3.3V#PD/PI/PU##BQ1833DV40DTPBFZP18LL_7LM.PAD
|   Base model BQ1833DV40DTPBFZP18LL_7LM
[Model Selector] Selector_6
Model_31 I/O,1.8V,PD
Model_32 I/O,1.8V,PU
Model_33 I/O,1.8V,PI
Model_34 I/O,3.3V,PD
Model_35 I/O,3.3V,PU
Model_36 I/O,3.3V,PI
|   Usage OD#1.8V/3.3V#PD/PI/PU##BC1833DV65ATPBFHP18LL_7LM_X50.PAD
|   Base model BC1833DV65ATPBFHP18LL_7LM_X50
[Model Selector] Selector_7
Model_19 I/O,1.8V,PD
Model_20 I/O,1.8V,PU
Model_21 I/O,1.8V,PI
Model_22 I/O,3.3V,PD
Model_23 I/O,3.3V,PU
Model_24 I/O,3.3V,PI
|   Usage IO#1.8V/3.3V#PD/PI/PU##BC1833DV40CTPBFZP18LL_7LM.PAD
|   Base model BC1833DV40CTPBFZP18LL_7LM
[Model Selector] Selector_8
Model_76 I/O,1.8V,PD
Model_77 I/O,1.8V,PU
Model_78 I/O,1.8V,PI
Model_79 I/O,3.3V,PD
Model_80 I/O,3.3V,PU
Model_81 I/O,3.3V,PI
|   Usage IO#1.8V/3.3V#PD/PI/PU##BC1833DV50BTPBFZP18LL_7LM_X50.PAD
|   Base model BC1833DV50BTPBFZP18LL_7LM_X50
[Model Selector] Selector_9
Model_94 I/O,1.8V,PD
Model_95 I/O,1.8V,PU
Model_96 I/O,1.8V,PI
Model_97 I/O,3.3V,PD
Model_98 I/O,3.3V,PU
Model_99 I/O,3.3V,PI
|   Usage IO#1.8V/3.3V#PD/PI/PU##BC1833DV65ATPBFHP18LL_7LM_X50.PAD
|   Base model BC1833DV65ATPBFHP18LL_7LM_X50
[Model Selector] Selector_10
Model_19 I/O,1.8V,PD
Model_20 I/O,1.8V,PU
Model_21 I/O,1.8V,PI
Model_22 I/O,3.3V,PD
Model_23 I/O,3.3V,PU
Model_24 I/O,3.3V,PI
|   Usage I#1.8V###IOSCHF18CVSHY_7LM.PAD
|   Base model IOSCHF18CVSHY_7LM
[Model Selector] Selector_11
Model_37 INPUT,1.8V
|   Usage IO#1.8V/3.3V#PD/PI/PU##BC1833DV40CTPBFHP18LL_7LM_X50.PAD
|   Base model BC1833DV40CTPBFHP18LL_7LM_X50
[Model Selector] Selector_12
Model_70 I/O,1.8V,PD
Model_71 I/O,1.8V,PU
Model_72 I/O,1.8V,PI
Model_73 I/O,3.3V,PD
Model_74 I/O,3.3V,PU
Model_75 I/O,3.3V,PI
|   Usage I#1.8V/3.3V#PD/PI/PU##IC1833DVTPBFZP18LL_7LM.PAD
|   Base model IC1833DVTPBFZP18LL_7LM
[Model Selector] Selector_13
Model_13 INPUT,1.8V,PD
Model_14 INPUT,1.8V,PU
Model_15 INPUT,1.8V,PI
Model_16 INPUT,3.3V,PD
Model_17 INPUT,3.3V,PU
Model_18 INPUT,3.3V,PI
|   Usage IO#1.8V/3.3V#PD/PI/PU##BC1833DV50BTPBFHP18LL_7LM.PAD
|   Base model BC1833DV50BTPBFHP18LL_7LM
[Model Selector] Selector_14
Model_134 I/O,1.8V,PD
Model_135 I/O,1.8V,PU
Model_136 I/O,1.8V,PI
Model_137 I/O,3.3V,PD
Model_138 I/O,3.3V,PU
Model_139 I/O,3.3V,PI
|   Usage I#1.8V/3.3V#PD/PI/PU##IC1833DVTPBFHP18LL_7LM.PAD
|   Base model IC1833DVTPBFHP18LL_7LM
[Model Selector] Selector_15
Model_44 INPUT,1.8V,PD
Model_45 INPUT,1.8V,PU
Model_46 INPUT,1.8V,PI
Model_47 INPUT,3.3V,PD
Model_48 INPUT,3.3V,PU
Model_49 INPUT,3.3V,PI
|   Usage IO#1.8V#FULL_SSTL/HALF_SSTL/NONE_SSTL#FAST#BSSTL18TCSCGPBFZ_7LM.PAD
|   Base model BSSTL18TCSCGPBFZ_7LM
[Model Selector] Selector_16
Model_100 INPUT,1.8V,HALF_SSTL,+-10%V
Model_102 3-STATE,1.8V,PI,FAST,+-10%V
Model_104 INPUT,1.8V,FULL_SSTL,+-10%V
Model_107 INPUT,1.8V,NONE_SSTL,+-10%V
Model_113 INPUT,1.8V,HALF_SSTL,+-0.1V
Model_115 3-STATE,1.8V,PI,FAST,+-0.1V
Model_117 INPUT,1.8V,FULL_SSTL,+-0.1V
Model_120 INPUT,1.8V,NONE_SSTL,+-0.1V
|   Usage I#1.8V/3.3V#PD/PI/PU##IQ1833DVTPBFZP18LL_7LM.PAD
|   Base model IQ1833DVTPBFZP18LL_7LM
[Model Selector] Selector_17
Model_82 INPUT,1.8V,PD
Model_83 INPUT,1.8V,PU
Model_84 INPUT,1.8V,PI
Model_85 INPUT,3.3V,PD
Model_86 INPUT,3.3V,PU
Model_87 INPUT,3.3V,PI
|   Usage IO#1.8V/3.3V#PD/PI/PU##BC1833DV50BTPBFHP18LL_7LM_X50.PAD
|   Base model BC1833DV50BTPBFHP18LL_7LM_X50
[Model Selector] Selector_18
Model_62 I/O,1.8V,PD
Model_63 I/O,1.8V,PU
Model_64 I/O,1.8V,PI
Model_65 I/O,3.3V,PD
Model_66 I/O,3.3V,PU
Model_67 I/O,3.3V,PI
|   Usage IO#1.8V/3.3V#PD/PI/PU##BQ1833DV40DTPBFHP18LL_7LM_X50.PAD
|   Base model BQ1833DV40DTPBFHP18LL_7LM_X50
[Model Selector] Selector_19
Model_50 I/O,1.8V,PD
Model_51 I/O,1.8V,PU
Model_52 I/O,1.8V,PI
Model_53 I/O,3.3V,PD
Model_54 I/O,3.3V,PU
Model_55 I/O,3.3V,PI
|   Usage O#1.8V/3.3V###BQ1833DV40DTPBFZP18LL_7LM_X50.PAD
|   Base model BQ1833DV40DTPBFZP18LL_7LM_X50
[Model Selector] Selector_20
Model_56 I/O,1.8V,PD
Model_57 I/O,1.8V,PU
Model_58 I/O,1.8V,PI
Model_59 I/O,3.3V,PD
Model_60 I/O,3.3V,PU
Model_61 I/O,3.3V,PI
|   Usage O#1.8V/3.3V###BQ1833DV40DTPBFHP18LL_7LM_X50.PAD
|   Base model BQ1833DV40DTPBFHP18LL_7LM_X50
[Model Selector] Selector_21
Model_50 I/O,1.8V,PD
Model_51 I/O,1.8V,PU
Model_52 I/O,1.8V,PI
Model_53 I/O,3.3V,PD
Model_54 I/O,3.3V,PU
Model_55 I/O,3.3V,PI
|   Usage I#1.8V/3.3V#PD/PI/PU##BQ1833DV40DTPBFHP18LL_7LM_X50.PAD
|   Base model BQ1833DV40DTPBFHP18LL_7LM_X50
[Model Selector] Selector_22
Model_50 I/O,1.8V,PD
Model_51 I/O,1.8V,PU
Model_52 I/O,1.8V,PI
Model_53 I/O,3.3V,PD
Model_54 I/O,3.3V,PU
Model_55 I/O,3.3V,PI
|   Usage I#1.8V/3.3V#PD/PI/PU##BQ1833DV50BTPBFZP18LL_7LM_X50.PAD
|   Base model BQ1833DV50BTPBFZP18LL_7LM_X50
[Model Selector] Selector_23
Model_88 I/O,1.8V,PD
Model_89 I/O,1.8V,PU
Model_90 I/O,1.8V,PI
Model_91 I/O,3.3V,PD
Model_92 I/O,3.3V,PU
Model_93 I/O,3.3V,PI
|   Usage I#1.8V/3.3V###IHHV1833DVTP18_7LM.PAD
|   Base model IHHV1833DVTP18_7LM
[Model Selector] Selector_24
Model_68 INPUT,1.8V
Model_69 INPUT,3.3V
|   Usage IO#1.8V/3.3V#PD/PI/PU##BC1833DV40CTPBFZP18LL_7LM_X50.PAD
|   Base model BC1833DV40CTPBFZP18LL_7LM_X50
[Model Selector] Selector_25
Model_38 I/O,1.8V,PD
Model_39 I/O,1.8V,PU
Model_40 I/O,1.8V,PI
Model_41 I/O,3.3V,PD
Model_42 I/O,3.3V,PU
Model_43 I/O,3.3V,PI
|   Usage IO#1.8V/3.3V#PD/PI/PU##BQ1833DV50BTPBFZP18LL_7LM_X50.PAD
|   Base model BQ1833DV50BTPBFZP18LL_7LM_X50
[Model Selector] Selector_26
Model_88 I/O,1.8V,PD
Model_89 I/O,1.8V,PU
Model_90 I/O,1.8V,PI
Model_91 I/O,3.3V,PD
Model_92 I/O,3.3V,PU
Model_93 I/O,3.3V,PI
|   Usage O#1.8V##FAST#BSSTL18TCSCGPBFZ_7LM.PAD
|   Base model BSSTL18TCSCGPBFZ_7LM
[Model Selector] Selector_27
Model_102 3-STATE,1.8V,PI,FAST,+-10%V
Model_115 3-STATE,1.8V,PI,FAST,+-0.1V
|   Usage IO#1.8V/3.3V#PD/PI/PU##BQ1833DV40DTPBFHP18LL_7LM.PAD
|   Base model BQ1833DV40DTPBFHP18LL_7LM
[Model Selector] Selector_28
Model_25 I/O,1.8V,PD
Model_26 I/O,1.8V,PU
Model_27 I/O,1.8V,PI
Model_28 I/O,3.3V,PD
Model_29 I/O,3.3V,PU
Model_30 I/O,3.3V,PI
| Package model definition
[Define Package Model]  am35xxzcn
[Manufacturer]   Texas Instruments.
[OEM]   Texas Instruments.
[Description]   am35xxzcn package model generated by GenIBIS.pl
[Number Of Pins]   287
[Pin Numbers]
A2   | 1 SDRC_DQS3P   IO
A3   | 2 SDRC_D25   IO
A4   | 3 SDRC_STRBEN_DLY1   IO
A5   | 4 SDRC_STRBEN1   IO
A6   | 5 SDRC_DQS2P   IO
A7   | 6 SDRC_D16   IO
A8   | 7 SDRC_A12   O
A9   | 8 SDRC_A10   O
A10   | 9 SDRC_A5   O
A11   | 10 SDRC_A0   O
A12   | 11 SDRC_BA0   O
A13   | 12 SDRC_CLK   O
A14   | 13 SDRC_NCS1   O
A15   | 14 SDRC_D15   IO
A16   | 15 SDRC_D14   IO
A17   | 16 SDRC_DQS1N   IO
A18   | 17 SDRC_STRBEN_DLY0   IO
A19   | 18 SDRC_STRBEN0   IO
A20   | 19 SDRC_DQS0N   IO
A21   | 20 SDRC_D1   IO
A22   | 21 MCBSP4_FSX   IO
A23   | 22 MCBSP4_DR   IO
A24   | 23 MCBSP3_CLKX   IO
AA1   | 24 SYS_BOOT1   IO
AA2   | 25 SYS_BOOT2   IO
AA3   | 26 SYS_BOOT3   IO
AA7   | 27 RMII_RXD1   IO
AA9   | 28 MMC1_CLK   IO
AA10   | 29 MMC1_DAT3   IO
AA16   | 30 MCSPI2_CS0   IO
AA18   | 31 ETK_D3   IO
AA19   | 32 UART1_TX   IO
AA23   | 33 DSS_DATA7   IO
AA24   | 34 DSS_DATA8   IO
AA25   | 35 DSS_DATA9   IO
AB1   | 36 SYS_BOOT4   IO
AB2   | 37 SYS_BOOT5   IO
AB6   | 38 CCDC_DATA6   IO
AB7   | 39 RMII_CRS_DV   IO
AB9   | 40 MMC1_CMD   IO
AB10   | 41 MMC1_DAT4   IO
AB12   | 42 MMC2_DAT0   IO
AB13   | 43 MMC2_DAT4   IO
AB15   | 44 MCSPI1_CS0   IO
AB16   | 45 MCSPI2_SOMI   IO
AB18   | 46 ETK_D2   IO
AB19   | 47 ETK_D7   IO
AB20   | 48 ETK_D11   IO
AB24   | 49 DSS_DATA5   IO
AB25   | 50 DSS_DATA6   IO
AC1   | 51 SYS_BOOT6   IO
AC2   | 52 SYS_BOOT7   I
AC3   | 53 SYS_BOOT8   I
AC5   | 54 CCDC_DATA2   IO
AC6   | 55 CCDC_DATA7   IO
AC7   | 56 RMII_RXER   IO
AC9   | 57 MMC1_DAT0   IO
AC10   | 58 MMC1_DAT5   IO
AC12   | 59 MMC2_DAT1   IO
AC13   | 60 MMC2_DAT5   IO
AC15   | 61 MCSPI1_SOMI   IO
AC16   | 62 MCSPI2_SIMO   IO
AC18   | 63 ETK_D1   IO
AC20   | 64 ETK_D10   IO
AC21   | 65 ETK_D14   IO
AC23   | 66 DSS_DATA2   IO
AC24   | 67 DSS_DATA3   IO
AC25   | 68 DSS_DATA4   IO
AD1   | 69 CCDC_FIELD   IO
AD2   | 70 CCDC_PCLK   IO
AD3   | 71 CCDC_VD   IO
AD4   | 72 CCDC_DATA0   IO
AD5   | 73 CCDC_DATA3   IO
AD6   | 74 RMII_MDIO_CLK   IO
AD7   | 75 RMII_TXD0   IO
AD8   | 76 RMII_TXEN   IO
AD9   | 77 MMC1_DAT1   IO
AD10   | 78 MMC1_DAT6   IO
AD11   | 79 MMC2_CLK   IO
AD12   | 80 MMC2_DAT2   IO
AD13   | 81 MMC2_DAT6   IO
AD14   | 82 MCSPI1_CS1   IO
AD15   | 83 MCSPI1_SIMO   IO
AD16   | 84 MCSPI2_CLK   IO
AD17   | 85 ETK_CLK   IO
AD18   | 86 ETK_D0   IO
AD19   | 87 ETK_D6   IO
AD20   | 88 ETK_D9   IO
AD21   | 89 ETK_D13   IO
AD22   | 90 DSS_HSYNC   IO
AD23   | 91 DSS_VSYNC   IO
AD24   | 92 DSS_DATA0   IO
AD25   | 93 DSS_DATA1   IO
AE2   | 94 CCDC_HD   IO
AE3   | 95 CCDC_WEN   IO
AE4   | 96 CCDC_DATA1   IO
AE5   | 97 CCDC_DATA4   IO
AE6   | 98 RMII_MDIO_DATA   IO
AE7   | 99 RMII_TXD1   IO
AE8   | 100 RMII_50MHZ_CLK   IO
AE9   | 101 MMC1_DAT2   IO
AE10   | 102 MMC1_DAT7   IO
AE11   | 103 MMC2_CMD   IO
AE12   | 104 MMC2_DAT3   IO
AE13   | 105 MMC2_DAT7   IO
AE14   | 106 MCSPI1_CLK   IO
AE15   | 107 MCSPI1_CS2   IO
AE16   | 108 MCSPI1_CS3   IO
AE17   | 109 MCSPI2_CS1   IO
AE18   | 110 ETK_CTL   IO
AE19   | 111 ETK_D5   IO
AE20   | 112 ETK_D8   IO
AE21   | 113 ETK_D12   IO
AE22   | 114 ETK_D15   IO
AE23   | 115 DSS_PCLK   IO
AE24   | 116 DSS_ACBIAS   IO
B1   | 117 SDRC_D30   IO
B2   | 118 SDRC_DQS3N   IO
B3   | 119 SDRC_D26   IO
B4   | 120 SDRC_D24   IO
B5   | 121 SDRC_D22   IO
B6   | 122 SDRC_DQS2N   IO
B7   | 123 SDRC_D17   IO
B8   | 124 SDRC_A13   O
B9   | 125 SDRC_A11   O
B10   | 126 SDRC_A6   O
B11   | 127 SDRC_A1   O
B13   | 128 SDRC_NCLK   O
B14   | 129 SDRC_NWE   O
B15   | 130 SDRC_DM1   O
B16   | 131 SDRC_D13   IO
B17   | 132 SDRC_DQS1P   IO
B18   | 133 SDRC_D8   IO
B19   | 134 SDRC_D7   IO
B20   | 135 SDRC_DQS0P   IO
B21   | 136 SDRC_D0   IO
B22   | 137 MCBSP4_DX   IO
B23   | 138 MCBSP4_CLKX   IO
B24   | 139 MCBSP3_DX   IO
B25   | 140 MCBSP2_DR   IO
C1   | 141 SDRC_D31   IO
C2   | 142 SDRC_D28   IO
C3   | 143 SDRC_D27   IO
C5   | 144 SDRC_D23   IO
C6   | 145 SDRC_D20   IO
C8   | 146 SDRC_ODT0   IO
C10   | 147 SDRC_A7   O
C11   | 148 SDRC_A2   O
C13   | 149 SDRC_BA1   O
C14   | 150 SDRC_NRAS   O
C16   | 151 SDRC_D12   IO
C17   | 152 SDRC_D10   IO
C19   | 153 SDRC_D6   IO
C20   | 154 SDRC_D3   IO
C21   | 155 SDRC_DM0   O
C23   | 156 MCBSP3_FSX   IO
C24   | 157 MCBSP3_DR   IO
C25   | 158 MCBSP2_CLKX   IO
D1   | 159 SDRC_DM3   O
D2   | 160 SDRC_D29   IO
D6   | 161 SDRC_D21   IO
D7   | 162 SDRC_D18   IO
D8   | 163 SDRC_A14   O
D10   | 164 SDRC_A8   O
D11   | 165 SDRC_A3   O
D13   | 166 SDRC_BA2   O
D14   | 167 SDRC_CKE0   O
D16   | 168 SDRC_D11   IO
D17   | 169 SDRC_D9   IO
D19   | 170 SDRC_D5   IO
D20   | 171 SDRC_D2   IO
D24   | 172 MCBSP2_DX   IO
D25   | 173 MCBSP2_FSX   IO
E1   | 174 GPMC_A3   IO
E2   | 175 GPMC_A2   IO
E3   | 176 GPMC_A1   IO
E7   | 177 SDRC_D19   IO
E8   | 178 SDRC_DM2   O
E10   | 179 SDRC_A9   O
E11   | 180 SDRC_A4   O
E13   | 181 SDRC_NCS0   O
E14   | 182 SDRC_NCAS   O
E19   | 183 SDRC_D4   IO
E23   | 184 UART2_RX   IO
E24   | 185 UART2_TX   IO
E25   | 186 USB0_DRVVBUS   IO
F1   | 187 GPMC_A9   IO
F2   | 188 GPMC_A8   IO
F3   | 189 GPMC_A7   IO
F4   | 190 GPMC_A6   IO
F6   | 191 GPMC_A5   IO
F7   | 192 GPMC_A4   IO
F19   | 193 UART2_RTS   IO
F20   | 194 UART2_CTS   IO
G1   | 195 GPMC_D4   IO
G2   | 196 GPMC_D3   IO
G3   | 197 GPMC_D2   IO
G4   | 198 GPMC_D1   IO
G5   | 199 GPMC_D0   IO
G6   | 200 GPMC_A10   IO
H1   | 201 GPMC_D6   IO
H2   | 202 GPMC_D5   IO
J1   | 203 GPMC_D11   IO
J2   | 204 GPMC_D10   IO
J3   | 205 GPMC_D9   IO
J4   | 206 GPMC_D8   IO
J5   | 207 GPMC_D7   IO
K1   | 208 GPMC_D15   IO
K2   | 209 GPMC_D14   IO
K3   | 210 GPMC_D13   IO
K4   | 211 GPMC_D12   IO
K24   | 212 SYS_32K   I
K25   | 213 SYS_XTALIN   I
L1   | 214 GPMC_NCS1   IO
L2   | 215 GPMC_NCS0   IO
L25   | 216 HDQ_SIO   IO
M1   | 217 GPMC_NCS5   IO
M2   | 218 GPMC_NCS4   IO
M3   | 219 GPMC_NCS3   IO
M4   | 220 GPMC_NCS2   IO
M24   | 221 SYS_CLKREQ   IO
M25   | 222 SYS_CLKOUT2   IO
N1   | 223 GPMC_CLK   IO
N2   | 224 UART3_CTS_RCTX   IO
N3   | 225 UART3_RTS_SD   IO
N4   | 226 GPMC_NCS7   IO
N5   | 227 GPMC_NCS6   IO
N24   | 228 MCBSP1_CLKX   IO
N25   | 229 SYS_CLKOUT1   IO
P1   | 230 UART3_RX_IRRX   IO
P2   | 231 UART3_TX_IRTX   IO
P21   | 232 MCBSP1_FSR   IO
P22   | 233 MCBSP1_DX   IO
P23   | 234 MCBSP1_DR   IO
P24   | 235 MCBSP1_FSX   IO
P25   | 236 MCBSP_CLKS   IO
R1   | 237 GPMC_NADV_ALE   O
R2   | 238 GPMC_NOE   O
R3   | 239 GPMC_NWE   O
R4   | 240 GPMC_NBE0_CLE   IO
R24   | 241 JTAG_EMU1   IO
R25   | 242 MCBSP1_CLKR   IO
T1   | 243 GPMC_NBE1   IO
T2   | 244 GPMC_NWP   IO
T3   | 245 GPMC_WAIT0   I
T4   | 246 GPMC_WAIT1   IO
T5   | 247 GPMC_WAIT2   IO
T21   | 248 JTAG_RTCK   O
T22   | 249 JTAG_TMS_TMSC   IO
T23   | 250 JTAG_TDI   I
T24   | 251 JTAG_TDO   O
T25   | 252 JTAG_EMU0   IO
U1   | 253 GPMC_WAIT3   IO
U21   | 254 DSS_DATA21   IO
U22   | 255 DSS_DATA22   IO
U23   | 256 DSS_DATA23   IO
U24   | 257 JTAG_NTRST   I
U25   | 258 JTAG_TCK   I
V2   | 259 HECC1_TXD   IO
V3   | 260 HECC1_RXD   IO
V4   | 261 I2C1_SCL   OD
V5   | 262 I2C1_SDA   OD
V24   | 263 DSS_DATA19   IO
V25   | 264 DSS_DATA20   IO
W1   | 265 I2C2_SCL   IO
W2   | 266 I2C2_SDA   IO
W4   | 267 I2C3_SCL   IO
W5   | 268 I2C3_SDA   IO
W20   | 269 UART1_RX   IO
W21   | 270 DSS_DATA14   IO
W22   | 271 DSS_DATA15   IO
W23   | 272 DSS_DATA16   IO
W24   | 273 DSS_DATA17   IO
W25   | 274 DSS_DATA18   IO
Y1   | 275 SYS_NIRQ   IO
Y2   | 276 SYS_NRESPWRON   I
Y3   | 277 SYS_NRESWARM   IO
Y4   | 278 SYS_BOOT0   IO
Y6   | 279 CCDC_DATA5   IO
Y7   | 280 RMII_RXD0   IO
Y18   | 281 ETK_D4   IO
Y19   | 282 UART1_RTS   IO
Y20   | 283 UART1_CTS   IO
Y22   | 284 DSS_DATA10   IO
Y23   | 285 DSS_DATA11   IO
Y24   | 286 DSS_DATA12   IO
Y25   | 287 DSS_DATA13   IO
[Model Data]
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[End Model Data]
[End Package Model]
| Models and submodels in the file (115): Model_1 (I/O), Model_2 (I/O), Model_3 (I/O), Model_4 (I/O), Model_5 (I/O), Model_6 (I/O), Model_7 (I/O), Model_8 (I/O), Model_9 (I/O), Model_10 (I/O), Model_11 (I/O), Model_12 (I/O), Model_13 (Input), Model_14 (Input), Model_15 (Input), Model_16 (Input), Model_17 (Input), Model_18 (Input), Model_19 (I/O), Model_20 (I/O), Model_21 (I/O), Model_22 (I/O), Model_23 (I/O), Model_24 (I/O), Model_25 (I/O), Model_26 (I/O), Model_27 (I/O), Model_28 (I/O), Model_29 (I/O), Model_30 (I/O), Model_31 (I/O), Model_32 (I/O), Model_33 (I/O), Model_34 (I/O), Model_35 (I/O), Model_36 (I/O), Model_37 (Input), Model_38 (I/O), Model_39 (I/O), Model_40 (I/O), Model_41 (I/O), Model_42 (I/O), Model_43 (I/O), Model_44 (Input), Model_45 (Input), Model_46 (Input), Model_47 (Input), Model_48 (Input), Model_49 (Input), Model_50 (I/O), Model_51 (I/O), Model_52 (I/O), Model_53 (I/O), Model_54 (I/O), Model_55 (I/O), Model_56 (I/O), Model_57 (I/O), Model_58 (I/O), Model_59 (I/O), Model_60 (I/O), Model_61 (I/O), Model_62 (I/O), Model_63 (I/O), Model_64 (I/O), Model_65 (I/O), Model_66 (I/O), Model_67 (I/O), Model_68 (Input), Model_69 (Input), Model_70 (I/O), Model_71 (I/O), Model_72 (I/O), Model_73 (I/O), Model_74 (I/O), Model_75 (I/O), Model_76 (I/O), Model_77 (I/O), Model_78 (I/O), Model_79 (I/O), Model_80 (I/O)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

| Texas Instruments Incorporated
| CDCLVP1102 1:2 Differential Buffer with one Clock Input
| CDCLVP1204 2:4 Differential Buffer with Selectable Clock Inputs
| CDCLVP1208 Low Jitter 8 Output LVPECL Buffer with Selectable Input
| CDCLVP1212 Low Jitter 12 Output LVPECL Buffer with Selectable Input
| CDCLVP1216 2:16 Differential LVPECL Buffer, High Performance Clock Buffer
| CDCLVP2102 Low Jitter Dual 1:2 LVPECL Buffer
| CDCLVP2104 Low Jitter Dual 1:4 LVPECL Buffer
| CDCLVP2106 Low Jitter Dual 1:6 LVPECL Buffer
| CDCLVP2108 1:8,16 LVPECL Output, no SEL pin,High Performance Clock Buffer
| Marketing part#   Voltage Range   Package-type   #pins/pkg drawing
| CDCLVP1102RGTR   2.375V - 3.6V   QFN   16-pin RGT
| CDCLVP1102RGTT   2.375V - 3.6V   QFN   16-pin RGT
| CDCLVP2102RGTR   2.375V - 3.6V   QFN   16-pin RGT
| CDCLVP2102RGTT   2.375V - 3.6V   QFN   16-pin RGT
| CDCLVP1204RGTR   2.375V - 3.6V   QFN   16-pin RGT
| CDCLVP1204RGTT   2.375V - 3.6V   QFN   16-pin RGT
| CDCLVP1216RGZR   2.375V - 3.6V   QFN   48-pin RGZ
| CDCLVP1216RGZT   2.375V - 3.6V   QFN   48-pin RGZ
| CDCLVP2108RGZR   2.375V - 3.6V   QFN   48-pin RGZ
| CDCLVP2108RGZT   2.375V - 3.6V   QFN   48-pin RGZ
| CDCLVP1212RHAR   2.375V - 3.6V   QFN   40-pin RHA
| CDCLVP1212RHAT   2.375V - 3.6V   QFN   40-pin RHA
| CDCLVP2106RHAR   2.375V - 3.6V   QFN   40-pin RHA
| CDCLVP2106RHAT   2.375V - 3.6V   QFN   40-pin RHA
| CDCLVP1208RHDR   2.375V - 3.6V   QFN   28-pin RHD
| CDCLVP1208RHDT   2.375V - 3.6V   QFN   28-pin RHD
| CDCLVP2104RHDR   2.375V - 3.6V   QFN   28-pin RHD
| CDCLVP2104RHDT   2.375V - 3.6V   QFN   28-pin RHD
[IBIS ver]   4.0
[File name]   cdclvpx.ibs
[File Rev]   1.1
[Date]   07/29/2009
[Source]   Spectre Simulations at:
   Texas Instruments Incorporated.
   Analog-eLab, HPA
   12500 TI Blvd
   Dallas, TX -75243
   For Support e-mail: elab_ibis@list.ti.com
[Notes]   Revision History
   Rev 1.0: 06/03/2009
   - Initial model generated from Spectre simulations
   - Initial version of the model not matched to
   measurements
   - Warnings related to VAC_REF clamp characterisitics
   can be ignored, as they represent true buffer characteristics
   - Initial IBIS file named cdclvp1102.ibs
   Rev 1.1: 07/29/2009
   - File name changed from cdclvp1102.ibs to cdclvpx.ibs
   - Added package models for CDCLVP2102,CDCLVP1204,CDCLVP1216,CDCLVP2108,
   CDCLVP1212, CDCLVP2106, CDCLVP1208, and CDCLVP2104. All these
   parts share same set of I/O buffers.
[Disclaimer] This model is designed as an aid for customers of Texas Instruments.
 TI and its licensors and suppliers make no warranties, either expressed
 or implied, with respect to this  model, including the warranties of
 merchantability or fitness for a particular purpose.
 The model is provided solely on an "as is" basis. The entire risk as to
 its quality and performance is with the customer.
[Copyright] (C)Copyright 2009 Texas Instruments Incorporated.
   All rights reserved.
|   Component CDCLVP1102RGT
[Component]   CDCLVP1102RGT
[Manufacturer]  Texas Instruments Incorporated
[Package]   |16-pin QFN RGT package
|   typ   min   max
R_pkg   0.2442   0.2257   0.2626
L_pkg   1.1009nH   1.0046nH   1.1974nH
C_pkg   0.1103pF   0.1081pF   0.1124pF
[Pin] signal_name  model_name   R_pin   L_pin   C_pin
   1   GND   GND   0.12037   0.82216nH   0.12472pF
   2   NC   NC   0.00244   0.06008nH   0.03612pF
   3   NC   NC   0.00244   0.06008nH   0.03612pF
   4   NC   NC   0.00244   0.06216nH   0.03162pF
   5   VCC   POWER   0.12566   0.86112nH   0.13739pF
   6   INP0   INPUT   0.22876   1.02355nH   0.11116pF
   7   INN0   INPUT   0.23258   1.04274nH   0.11153pF
   8   VAC_REF   VAC_REF   0.26260   1.19735nH   0.11242pF
   9   OUTP0   PECL_OUT   0.25027   1.13306nH   0.10811pF
   10   OUTN0   PECL_OUT   0.22571   1.00464nH   0.10867pF
   11   OUTP1   PECL_OUT   0.22940   1.02114nH   0.11008pF
   12   OUTN1   PECL_OUT   0.25984   1.17646nH   0.11074pF
   13   NC   NC   0.00244   0.06216nH   0.03162pF
   14   NC   NC   0.00244   0.06008nH   0.03612pF
   15   NC   NC   0.00244   0.06008nH   0.03612pF
   16   GND   GND   0.12148   0.82689nH   0.12554pF
[Diff_Pin]  inv_pin  vdiff   tdelay_typ  tdelay_min  tdelay_max
| The '+' pin is   Diff_pin,   the '-' pin is the   Inv_pin
| Receiver Pins  |  Receiver Vth = +/-200mV
6   7   0.8V   0ns   0ns   0ns
| LVPECL Driver Pins
9   10   0.5V   0ns   0ns   0ns
11   12   0.5V   0ns   0ns   0ns
|   Component CDCLVP2102RGT
[Component]   CDCLVP2102RGT
[Manufacturer]  Texas Instruments Incorporated
[Package]   |16-pin QFN RGT package
|   typ   min   max
R_pkg   0.2458   0.2257   0.2658
L_pkg   1.1055nH   1.0046nH   1.2064nH
C_pkg   0.1092pF   0.1051pF   0.1132pF
[Pin] signal_name  model_name   R_pin   L_pin   C_pin
   1   GND   GND   0.12037   0.82216nH   0.12819pF
   2   NC   NC   0.00244   0.06008nH   0.03612pF
   3   INP1   INPUT   0.22606   1.00656nH   0.10507pF
   4   INN1   INPUT   0.25236   1.14386nH   0.10913pF
   5   VCC   POWER   0.08325   0.79299nH   0.15518pF
   6   INP0   INPUT   0.22876   1.02355nH   0.11162pF
   7   INN0   INPUT   0.23258   1.04274nH   0.11159pF
   8   VAC_REF   VAC_REF   0.26260   1.19735nH   0.11246pF
   9   OUTP0   PECL_OUT   0.25027   1.13306nH   0.10814pF
   10   OUTN0   PECL_OUT   0.22571   1.00464nH   0.10870pF
   11   OUTP1   PECL_OUT   0.22940   1.02114nH   0.11016pF
   12   OUTN1   PECL_OUT   0.25984   1.17646nH   0.11123pF
   13   OUTP2   PECL_OUT   0.26581   1.20636nH   0.11324pF
   14   OUTN2   PECL_OUT   0.23400   1.04124nH   0.11179pF
   15   OUTP3   PECL_OUT   0.22794   1.01049nH   0.10931pF
   16   OUTN3   PECL_OUT   0.25004   1.12526nH   0.10844pF
[Diff_Pin]  inv_pin  vdiff   tdelay_typ  tdelay_min  tdelay_max
| The '+' pin is   Diff_pin,   the '-' pin is the   Inv_pin
| Receiver Pins  |  Receiver Vth = +/-200mV
3   4   0.8V   0ns   0ns   0ns
6   7   0.8V   0ns   0ns   0ns
| LVPECL Driver Pins
9   10   0.5V   0ns   0ns   0ns
11   12   0.5V   0ns   0ns   0ns
13   14   0.5V   0ns   0ns   0ns
15   16   0.5V   0ns   0ns   0ns
|   Component CDCLVP1204RGT
[Component]   CDCLVP1204RGT
[Manufacturer]  Texas Instruments Incorporated
[Package]   |16-pin QFN RGT package
|   typ   min   max
R_pkg   0.2458   0.2257   0.2658
L_pkg   1.1055nH   1.0046nH   1.2064nH
C_pkg   0.1103pF   0.1073pF   0.1133pF
[Pin] signal_name  model_name   R_pin   L_pin   C_pin
   1   GND   GND   0.12037   0.82216nH   0.12819pF
   2   IN_SEL   SEL_IN   0.22773   1.01285nH   0.10730pF
   3   INP1   INPUT   0.22606   1.00656nH   0.10882pF
   4   INN1   INPUT   0.25236   1.14386nH   0.10955pF
   5   VCC   POWER   0.08325   0.79299nH   0.15524pF
   6   INP0   INPUT   0.22876   1.02355nH   0.11162pF
   7   INN0   INPUT   0.23258   1.04274nH   0.11160pF
   8   VAC_REF   VAC_REF   0.26260   1.19735nH   0.11246pF
   9   OUTP0   PECL_OUT   0.25027   1.13306nH   0.10814pF
   10   OUTN0   PECL_OUT   0.22571   1.00464nH   0.10870pF
   11   OUTP1   PECL_OUT   0.22940   1.02114nH   0.11017pF
   12   OUTN1   PECL_OUT   0.25984   1.17646nH   0.11124pF
   13   OUTP2   PECL_OUT   0.26581   1.20636nH   0.11325pF
   14   OUTN2   PECL_OUT   0.23400   1.04124nH   0.11180pF
   15   OUTP3   PECL_OUT   0.22794   1.01049nH   0.10933pF
   16   OUTN3   PECL_OUT   0.25004   1.12526nH   0.10849pF
[Diff_Pin]  inv_pin  vdiff   tdelay_typ  tdelay_min  tdelay_max
| The '+' pin is   Diff_pin,   the '-' pin is the   Inv_pin
| Receiver Pins  |  Receiver Vth = +/-200mV
3   4   0.8V   0ns   0ns   0ns
6   7   0.8V   0ns   0ns   0ns
| LVPECL Driver Pins
9   10   0.5V   0ns   0ns   0ns
11   12   0.5V   0ns   0ns   0ns
13   14   0.5V   0ns   0ns   0ns
15   16   0.5V   0ns   0ns   0ns
[series pin mapping]  pin_2   model_name
2   1   PDN_SEL_IN
|   Component CDCLVP1216RGZ
[Component]   CDCLVP1216RGZ
[Manufacturer]  Texas Instruments Incorporated
[Package]   |48-pin QFN RGZ, 7mm X 7mm package
|   typ   min   max
R_pkg   0.588   0.510   0.665
L_pkg   2.957nH   2.542nH   3.371nH
C_pkg   0.272pF   0.247pF   0.297pF
[Pin] signal_name  model_name   R_pin   L_pin   C_pin
   1   GND   GND   0.65656   3.33539nH   0.28003pF
   2   IN_SEL   SEL_IN   0.61157   3.08921nH   0.28915pF
   3   INP1   INPUT   0.57343   2.88428nH   0.27264pF
   4   INN1   INPUT   0.54341   2.72363nH   0.25062pF
   5   NC   NC   0.00473   0.11459nH   0.07856pF
   6   VCC   POWER   0.25969   2.00218nH   0.30564pF
   7   VCC   POWER   0.51372   2.56508nH   0.24941pF
   8   VAC_REF   VAC_REF   0.52312   2.61529nH   0.25165pF
   9   INN0   INPUT   0.54343   2.72383nH   0.25978pF
   10   INP0   INPUT   0.57346   2.88448nH   0.26061pF
   11   NC   NC   0.00473   0.11551nH   0.07850pF
   12   GND   GND   0.65660   3.33559nH   0.26143pF
   13   VCC   POWER   0.65496   3.32619nH   0.27810pF
   14   OUTP0   PECL_OUT   0.61059   3.08261nH   0.28822pF
   15   OUTN0   PECL_OUT   0.57193   2.87407nH   0.27296pF
   16   OUTP1   PECL_OUT   0.54137   2.70952nH   0.26007pF
   17   OUTN1   PECL_OUT   0.52043   2.59668nH   0.25132pF
   18   OUTP2   PECL_OUT   0.51043   2.54238nH   0.24716pF
   19   OUTN2   PECL_OUT   0.51205   2.55018nH   0.24780pF
   20   OUTP3   PECL_OUT   0.52519   2.61949nH   0.25320pF
   21   OUTN3   PECL_OUT   0.54894   2.74573nH   0.26313pF
   22   OUTP4   PECL_OUT   0.58191   2.92178nH   0.27726pF
   23   OUTN4   PECL_OUT   0.62252   3.13971nH   0.29741pF
   24   VCC   POWER   0.33317   2.81171nH   0.35197pF
   25   OUTP5   PECL_OUT   0.66500   3.37178nH   0.28261pF
   26   OUTN5   PECL_OUT   0.61921   3.12071nH   0.29202pF
   27   OUTP6   PECL_OUT   0.57979   2.90827nH   0.27574pF
   28   OUTN6   PECL_OUT   0.54821   2.73883nH   0.26237pF
   29   OUTP7   PECL_OUT   0.52603   2.61989nH   0.25309pF
   30   OUTN7   PECL_OUT   0.51455   2.55838nH   0.24823pF
   31   OUTP8   PECL_OUT   0.51455   2.55838nH   0.24822pF
   32   OUTN8   PECL_OUT   0.52601   2.61979nH   0.25309pF
   33   OUTP9   PECL_OUT   0.54819   2.73873nH   0.26236pF
   34   OUTN9   PECL_OUT   0.57976   2.90818nH   0.27572pF
   35   OUTP10   PECL_OUT   0.61918   3.12051nH   0.29200pF
   36   OUTN10   PECL_OUT   0.66496   3.37159nH   0.28258pF
   37   VCC   POWER   0.33314   2.82774nH   0.35201pF
   38   OUTP11   PECL_OUT   0.62248   3.13941nH   0.29741pF
   39   OUTN11   PECL_OUT   0.58186   2.92147nH   0.27725pF
   40   OUTP12   PECL_OUT   0.54889   2.74553nH   0.26312pF
   41   OUTN12   PECL_OUT   0.52513   2.61919nH   0.25318pF
   42   OUTP13   PECL_OUT   0.51200   2.54988nH   0.24778pF
   43   OUTN13   PECL_OUT   0.51036   2.54206nH   0.24716pF
   44   OUTP14   PECL_OUT   0.52038   2.59649nH   0.25131pF
   45   OUTN14   PECL_OUT   0.54131   2.70921nH   0.26007pF
   46   OUTP15   PECL_OUT   0.57189   2.87377nH   0.27298pF
   47   OUTN15   PECL_OUT   0.61053   3.08229nH   0.28833pF
   48   VCC   POWER   0.65491   3.32598nH   0.27862pF
[Diff_Pin]  inv_pin  vdiff   tdelay_typ  tdelay_min  tdelay_max
| The '+' pin is   Diff_pin,   the '-' pin is the   Inv_pin
| Receiver Pins  |  Receiver Vth = +/-200mV
3   4   0.8V   0ns   0ns   0ns
9   10   0.8V   0ns   0ns   0ns
| LVPECL Driver Pins
14   15   0.5V   0ns   0ns   0ns
16   17   0.5V   0ns   0ns   0ns
18   19   0.5V   0ns   0ns   0ns
20   21   0.5V   0ns   0ns   0ns
22   23   0.5V   0ns   0ns   0ns
25   26   0.5V   0ns   0ns   0ns
27   28   0.5V   0ns   0ns   0ns
29   30   0.5V   0ns   0ns   0ns
31   32   0.5V   0ns   0ns   0ns
33   34   0.5V   0ns   0ns   0ns
35   36   0.5V   0ns   0ns   0ns
38   39   0.5V   0ns   0ns   0ns
40   41   0.5V   0ns   0ns   0ns
42   43   0.5V   0ns   0ns   0ns
44   45   0.5V   0ns   0ns   0ns
46   47   0.5V   0ns   0ns   0ns
[series pin mapping]  pin_2   model_name
2   1   PDN_SEL_IN
|   Component CDCLVP1216RGZ
[Component]   CDCLVP2108RGZ
[Manufacturer]  Texas Instruments Incorporated
[Package]   |48-pin QFN RGZ, 7mm X 7mm package
|   typ   min   max
R_pkg   0.588   0.510   0.665
L_pkg   2.957nH   2.542nH   3.371nH
C_pkg   0.272pF   0.247pF   0.297pF
[Pin] signal_name  model_name   R_pin   L_pin   C_pin
   1   GND   GND   0.65656   3.33539nH   0.28003pF
   2   NC   NC   0.00473   0.11551nH   0.07850pF
   3   INP1   INPUT   0.57343   2.88428nH   0.27264pF
   4   INN1   INPUT   0.54341   2.72363nH   0.25062pF
   5   VAC_REF1   VAC_REF   0.52311   2.61519nH   0.25495pF
   6   VCC   POWER   0.25969   2.00218nH   0.30564pF
   7   VCC   POWER   0.51372   2.56508nH   0.24941pF
   8   VAC_REF0   VAC_REF   0.52312   2.61529nH   0.25165pF
   9   INN0   INPUT   0.54343   2.72383nH   0.25978pF
   10   INP0   INPUT   0.57346   2.88448nH   0.26061pF
   11   NC   NC   0.00473   0.11551nH   0.07850pF
   12   GND   GND   0.65660   3.33559nH   0.26143pF
   13   VCC   POWER   0.65496   3.32619nH   0.27810pF
   14   OUTP0   PECL_OUT   0.61059   3.08261nH   0.28822pF
   15   OUTN0   PECL_OUT   0.57193   2.87407nH   0.27296pF
   16   OUTP1   PECL_OUT   0.54137   2.70952nH   0.26007pF
   17   OUTN1   PECL_OUT   0.52043   2.59668nH   0.25132pF
   18   OUTP2   PECL_OUT   0.51043   2.54238nH   0.24716pF
   19   OUTN2   PECL_OUT   0.51205   2.55018nH   0.24780pF
   20   OUTP3   PECL_OUT   0.52519   2.61949nH   0.25320pF
   21   OUTN3   PECL_OUT   0.54894   2.74573nH   0.26313pF
   22   OUTP4   PECL_OUT   0.58191   2.92178nH   0.27726pF
   23   OUTN4   PECL_OUT   0.62252   3.13971nH   0.29741pF
   24   VCC   POWER   0.33317   2.81171nH   0.35197pF
   25   OUTP5   PECL_OUT   0.66500   3.37178nH   0.28261pF
   26   OUTN5   PECL_OUT   0.61921   3.12071nH   0.29202pF
   27   OUTP6   PECL_OUT   0.57979   2.90827nH   0.27574pF
   28   OUTN6   PECL_OUT   0.54821   2.73883nH   0.26237pF
   29   OUTP7   PECL_OUT   0.52603   2.61989nH   0.25309pF
   30   OUTN7   PECL_OUT   0.51455   2.55838nH   0.24823pF
   31   OUTP8   PECL_OUT   0.51455   2.55838nH   0.24822pF
   32   OUTN8   PECL_OUT   0.52601   2.61979nH   0.25309pF
   33   OUTP9   PECL_OUT   0.54819   2.73873nH   0.26236pF
   34   OUTN9   PECL_OUT   0.57976   2.90818nH   0.27572pF
   35   OUTP10   PECL_OUT   0.61918   3.12051nH   0.29200pF
   36   OUTN10   PECL_OUT   0.66496   3.37159nH   0.28258pF
   37   VCC   POWER   0.33314   2.82774nH   0.35201pF
   38   OUTP11   PECL_OUT   0.62248   3.13941nH   0.29741pF
   39   OUTN11   PECL_OUT   0.58186   2.92147nH   0.27725pF
   40   OUTP12   PECL_OUT   0.54889   2.74553nH   0.26312pF
   41   OUTN12   PECL_OUT   0.52513   2.61919nH   0.25318pF
   42   OUTP13   PECL_OUT   0.51200   2.54988nH   0.24778pF
   43   OUTN13   PECL_OUT   0.51036   2.54206nH   0.24716pF
   44   OUTP14   PECL_OUT   0.52038   2.59649nH   0.25131pF
   45   OUTN14   PECL_OUT   0.54131   2.70921nH   0.26007pF
   46   OUTP15   PECL_OUT   0.57189   2.87377nH   0.27298pF
   47   OUTN15   PECL_OUT   0.61053   3.08229nH   0.28833pF
   48   VCC   POWER   0.65491   3.32598nH   0.27862pF
[Diff_Pin]  inv_pin  vdiff   tdelay_typ  tdelay_min  tdelay_max
| The '+' pin is   Diff_pin,   the '-' pin is the   Inv_pin
| Receiver Pins  |  Receiver Vth = +/-200mV
3   4   0.8V   0ns   0ns   0ns
9   10   0.8V   0ns   0ns   0ns
| LVPECL Driver Pins
14   15   0.5V   0ns   0ns   0ns
16   17   0.5V   0ns   0ns   0ns
18   19   0.5V   0ns   0ns   0ns
20   21   0.5V   0ns   0ns   0ns
22   23   0.5V   0ns   0ns   0ns
25   26   0.5V   0ns   0ns   0ns
27   28   0.5V   0ns   0ns   0ns
29   30   0.5V   0ns   0ns   0ns
31   32   0.5V   0ns   0ns   0ns
33   34   0.5V   0ns   0ns   0ns
35   36   0.5V   0ns   0ns   0ns
38   39   0.5V   0ns   0ns   0ns
40   41   0.5V   0ns   0ns   0ns
42   43   0.5V   0ns   0ns   0ns
44   45   0.5V   0ns   0ns   0ns
46   47   0.5V   0ns   0ns   0ns
|   Component CDCLVP1212RHA
[Component]   CDCLVP1212RHA
[Manufacturer]  Texas Instruments Incorporated
[Package]   |40-pin QFN RHA, 6mm X 6mm package
|   typ   min   max
R_pkg   0.479   0.421   0.537
L_pkg   2.328nH   2.014nH   2.641nH
C_pkg   0.205pF   0.184pF   0.226pF
[Pin] signal_name  model_name   R_pin   L_pin   C_pin
   1   IN_SEL   SEL_IN   0.53663   2.64121nH   0.21428pF
   2   INP1   INPUT   0.49495   2.41562nH   0.22153pF
   3   INN1   INPUT   0.45957   2.22655nH   0.19938pF
   4   NC   NC   0.00171   0.04929nH   0.05222pF
   5   VCC   POWER   0.21322   1.56144nH   0.24182pF
   6   VCC   POWER   0.42364   2.03554nH   0.19378pF
   7   VAC_REF   VAC_REF   0.43514   2.09659nH   0.19724pF
   8   INN0   INPUT   0.45959   2.22665nH   0.20687pF
   9   INP0   INPUT   0.49499   2.41572nH   0.20752pF
   10   NC   NC   0.00171   0.05331nH   0.04134pF
   11   VCC   POWER   0.52466   2.57661nH   0.19722pF
   12   OUTP0   PECL_OUT   0.50327   2.45872nH   0.21745pF
   13   OUTN0   PECL_OUT   0.46514   2.25385nH   0.20998pF
   14   OUTP1   PECL_OUT   0.43728   2.10459nH   0.19877pF
   15   OUTN1   PECL_OUT   0.42197   2.02214nH   0.19250pF
   16   OUTP2   PECL_OUT   0.42072   2.01434nH   0.19197pF
   17   OUTN2   PECL_OUT   0.43367   2.08219nH   0.19731pF
   18   OUTP3   PECL_OUT   0.45950   2.21885nH   0.20822pF
   19   OUTN3   PECL_OUT   0.49602   2.41352nH   0.22636pF
   20   VCC   POWER   0.26646   2.10219nH   0.28000pF
   21   GND   GND   0.52445   2.56751nH   0.21245pF
   22   OUTP4   PECL_OUT   0.48448   2.35042nH   0.21789pF
   23   OUTN4   PECL_OUT   0.45183   2.17535nH   0.20432pF
   24   OUTP5   PECL_OUT   0.43066   2.06239nH   0.19495pF
   25   OUTN5   PECL_OUT   0.42289   2.02094nH   0.18444pF
   26   OUTP6   PECL_OUT   0.42289   2.02094nH   0.18443pF
   27   OUTN6   PECL_OUT   0.43065   2.06229nH   0.19494pF
   28   OUTP7   PECL_OUT   0.45180   2.17525nH   0.20432pF
   29   OUTN7   PECL_OUT   0.48445   2.35022nH   0.21788pF
   30   GND   GND   0.52441   2.56731nH   0.21245pF
   31   VCC   POWER   0.26643   2.10828nH   0.28002pF
   32   OUTP8   PECL_OUT   0.49598   2.41332nH   0.22636pF
   33   OUTN8   PECL_OUT   0.45945   2.21865nH   0.20820pF
   34   OUTP9   PECL_OUT   0.43362   2.08189nH   0.19730pF
   35   OUTN9   PECL_OUT   0.42067   2.01414nH   0.19196pF
   36   OUTP10   PECL_OUT   0.42192   2.02184nH   0.19248pF
   37   OUTN10   PECL_OUT   0.43723   2.10429nH   0.19877pF
   38   OUTP11   PECL_OUT   0.46509   2.25365nH   0.21002pF
   39   OUTN11   PECL_OUT   0.50323   2.45852nH   0.21772pF
   40   VCC   POWER   0.52461   2.57631nH   0.20060pF
[Diff_Pin]  inv_pin  vdiff   tdelay_typ  tdelay_min  tdelay_max
| The '+' pin is   Diff_pin,   the '-' pin is the   Inv_pin
| Receiver Pins  |  Receiver Vth = +/-200mV
2   3   0.8V   0ns   0ns   0ns
8   9   0.8V   0ns   0ns   0ns
| LVPECL Driver Pins
12   13   0.5V   0ns   0ns   0ns
14   15   0.5V   0ns   0ns   0ns
16   17   0.5V   0ns   0ns   0ns
18   19   0.5V   0ns   0ns   0ns
22   23   0.5V   0ns   0ns   0ns
24   25   0.5V   0ns   0ns   0ns
26   27   0.5V   0ns   0ns   0ns
28   29   0.5V   0ns   0ns   0ns
32   33   0.5V   0ns   0ns   0ns
34   35   0.5V   0ns   0ns   0ns
36   37   0.5V   0ns   0ns   0ns
38   39   0.5V   0ns   0ns   0ns
[series pin mapping]  pin_2   model_name
1   21   PDN_SEL_IN
|   Component CDCLVP2106RHA
[Component]   CDCLVP2106RHA
[Manufacturer]  Texas Instruments Incorporated
[Package]   |40-pin QFN RHA, 6mm X 6mm package
|   typ   min   max
R_pkg   0.462   0.421   0.503
L_pkg   2.326nH   2.014nH   2.659nH
C_pkg   0.205pF   0.184pF   0.226pF
[Pin] signal_name  model_name   R_pin   L_pin   C_pin
   1   NC   NC   0.00171   0.05331nH   0.04133pF
   2   INP1   INPUT   0.49495   2.41562nH   0.22153pF
   3   INN1   INPUT   0.45957   2.22655nH   0.19938pF
   4   VAC_REF1   VAC_REF   0.43512   2.09649nH   0.19991pF
   5   VCC   POWER   0.21322   1.56144nH   0.24182pF
   6   VCC   POWER   0.42364   2.03554nH   0.19378pF
   7   VAC_REF0   VAC_REF   0.43514   2.09659nH   0.19724pF
   8   INN0   INPUT   0.45959   2.22665nH   0.20687pF
   9   INP0   INPUT   0.49499   2.41572nH   0.20752pF
   10   NC   NC   0.00171   0.05331nH   0.04134pF
   11   VCC   POWER   0.52466   2.57661nH   0.19722pF
   12   OUTP0   PECL_OUT   0.50327   2.45872nH   0.21745pF
   13   OUTN0   PECL_OUT   0.46514   2.25385nH   0.20998pF
   14   OUTP1   PECL_OUT   0.43728   2.10459nH   0.19877pF
   15   OUTN1   PECL_OUT   0.42197   2.02214nH   0.19250pF
   16   OUTP2   PECL_OUT   0.42072   2.01434nH   0.19197pF
   17   OUTN2   PECL_OUT   0.43367   2.08219nH   0.19731pF
   18   OUTP3   PECL_OUT   0.45950   2.21885nH   0.20822pF
   19   OUTN3   PECL_OUT   0.49602   2.41352nH   0.22636pF
   20   VCC   POWER   0.26646   2.10219nH   0.28000pF
   21   GND   GND   0.52445   2.56751nH   0.21245pF
   22   OUTP4   PECL_OUT   0.48448   2.35042nH   0.21789pF
   23   OUTN4   PECL_OUT   0.45183   2.17535nH   0.20432pF
   24   OUTP5   PECL_OUT   0.43066   2.06239nH   0.19495pF
   25   OUTN5   PECL_OUT   0.42289   2.02094nH   0.18444pF
   26   OUTP6   PECL_OUT   0.42289   2.02094nH   0.18443pF
   27   OUTN6   PECL_OUT   0.43065   2.06229nH   0.19494pF
   28   OUTP7   PECL_OUT   0.45180   2.17525nH   0.20432pF
   29   OUTN7   PECL_OUT   0.48445   2.35022nH   0.21788pF
   30   GND   GND   0.52441   2.56731nH   0.21245pF
   31   VCC   POWER   0.26643   2.10828nH   0.28002pF
   32   OUTP8   PECL_OUT   0.49598   2.41332nH   0.22636pF
   33   OUTN8   PECL_OUT   0.45945   2.21865nH   0.20820pF
   34   OUTP9   PECL_OUT   0.43362   2.08189nH   0.19730pF
   35   OUTN9   PECL_OUT   0.42067   2.01414nH   0.19196pF
   36   OUTP10   PECL_OUT   0.42192   2.02184nH   0.19248pF
   37   OUTN10   PECL_OUT   0.43723   2.10429nH   0.19877pF
   38   OUTP11   PECL_OUT   0.46509   2.25365nH   0.21002pF
   39   OUTN11   PECL_OUT   0.50323   2.45852nH   0.21772pF
   40   VCC   POWER   0.52461   2.57631nH   0.20060pF
[Diff_Pin]  inv_pin  vdiff   tdelay_typ  tdelay_min  tdelay_max
| The '+' pin is   Diff_pin,   the '-' pin is the   Inv_pin
| Receiver Pins  |  Receiver Vth = +/-200mV
2   3   0.8V   0ns   0ns   0ns
8   9   0.8V   0ns   0ns   0ns
| LVPECL Driver Pins
12   13   0.5V   0ns   0ns   0ns
14   15   0.5V   0ns   0ns   0ns
16   17   0.5V   0ns   0ns   0ns
18   19   0.5V   0ns   0ns   0ns
22   23   0.5V   0ns   0ns   0ns
24   25   0.5V   0ns   0ns   0ns
26   27   0.5V   0ns   0ns   0ns
28   29   0.5V   0ns   0ns   0ns
32   33   0.5V   0ns   0ns   0ns
34   35   0.5V   0ns   0ns   0ns
36   37   0.5V   0ns   0ns   0ns
38   39   0.5V   0ns   0ns   0ns
|   Component CDCLVP1208RHD
[Component]   CDCLVP1208RHD
[Manufacturer]  Texas Instruments Incorporated
[Package]   |28-pin QFN RHD, 5mm X 5mm package
|   typ   min   max
R_pkg   0.376   0.336   0.416
L_pkg   1.773nH   1.560nH   1.986nH
C_pkg   0.184pF   0.173pF   0.196pF
[Pin] signal_name  model_name   R_pin   L_pin   C_pin
   1   GND   GND   0.20205   1.54413nH   0.22779pF
   2   OUTP7   PECL_OUT   0.36833   1.73054nH   0.19140pF
   3   OUTN7   PECL_OUT   0.34356   1.60090nH   0.17840pF
   4   IN_SEL   SEL_IN   0.33554   1.56003nH   0.17503pF
   5   INP1   INPUT   0.34557   1.61410nH   0.17912pF
   6   INN1   INPUT   0.37204   1.75504nH   0.18953pF
   7   VAC_REF   VAC_REF   0.41113   1.96558nH   0.17941pF
   8   VCC   POWER   0.20608   1.47220nH   0.23933pF
   9   INP0   INPUT   0.38079   1.80314nH   0.19569pF
   10   INN0   INPUT   0.35247   1.65370nH   0.17560pF
   11   NC   NC   0.00139   0.04443nH   0.06337pF
   12   OUTP0   PECL_OUT   0.34512   1.61530nH   0.17275pF
   13   OUTN0   PECL_OUT   0.36718   1.73174nH   0.18738pF
   14   GND   GND   0.40372   1.92738nH   0.17766pF
   15   VCC   POWER   0.20323   1.55915nH   0.22711pF
   16   OUTP1   PECL_OUT   0.37026   1.74564nH   0.19232pF
   17   OUTN1   PECL_OUT   0.34486   1.61030nH   0.17896pF
   18   OUTP2   PECL_OUT   0.33606   1.56273nH   0.17520pF
   19   OUTN2   PECL_OUT   0.34529   1.60990nH   0.17885pF
   20   OUTP3   PECL_OUT   0.37105   1.74484nH   0.18893pF
   21   OUTN3   PECL_OUT   0.40991   1.95238nH   0.17780pF
   22   OUTP4   PECL_OUT   0.41637   1.98558nH   0.17997pF
   23   OUTN4   PECL_OUT   0.37690   1.77334nH   0.19100pF
   24   OUTP5   PECL_OUT   0.35016   1.63170nH   0.18046pF
   25   OUTN5   PECL_OUT   0.33957   1.57583nH   0.17618pF
   26   OUTP6   PECL_OUT   0.34680   1.61400nH   0.17927pF
   27   OUTN6   PECL_OUT   0.37068   1.74054nH   0.19195pF
   28   VCC   POWER   0.20285   1.53973nH   0.22849pF
[Diff_Pin]  inv_pin  vdiff   tdelay_typ  tdelay_min  tdelay_max
| The '+' pin is   Diff_pin,   the '-' pin is the   Inv_pin
| Receiver Pins  |  Receiver Vth = +/-200mV
5   6   0.8V   0ns   0ns   0ns
9   10   0.8V   0ns   0ns   0ns
| LVPECL Driver Pins
2   3   0.5V   0ns   0ns   0ns
12   13   0.5V   0ns   0ns   0ns
16   17   0.5V   0ns   0ns   0ns
18   19   0.5V   0ns   0ns   0ns
20   21   0.5V   0ns   0ns   0ns
22   23   0.5V   0ns   0ns   0ns
24   25   0.5V   0ns   0ns   0ns
26   27   0.5V   0ns   0ns   0ns
[series pin mapping]  pin_2   model_name
4   1   PDN_SEL_IN
|   Component CDCLVP2104RHD
[Component]   CDCLVP2104RHD
[Manufacturer]  Texas Instruments Incorporated
[Package]   |28-pin QFN RHD, 5mm X 5mm package
|   typ   min   max
R_pkg   0.376   0.336   0.416
L_pkg   1.773nH   1.560nH   1.986nH
C_pkg   0.184pF   0.173pF   0.196pF
[Pin] signal_name  model_name   R_pin   L_pin   C_pin
   1   GND   GND   0.20205   1.54413nH   0.22779pF
   2   OUTP7   PECL_OUT   0.36833   1.73054nH   0.19140pF
   3   OUTN7   PECL_OUT   0.34356   1.60090nH   0.17840pF
   4   NC   NC   0.00139   0.04443nH   0.06337pF
   5   INP1   INPUT   0.34557   1.61410nH   0.17912pF
   6   INN1   INPUT   0.37204   1.75504nH   0.18953pF
   7   VAC_REF1   VAC_REF   0.41113   1.96558nH   0.17941pF
   8   VCC   POWER   0.20608   1.47220nH   0.23933pF
   9   INP0   INPUT   0.38079   1.80314nH   0.19569pF
   10   INN0   INPUT   0.35247   1.65370nH   0.17560pF
   11   VAC_REF0   VAC_REF   0.00139   0.04443nH   0.06337pF
   12   OUTP0   PECL_OUT   0.34512   1.61530nH   0.17275pF
   13   OUTN0   PECL_OUT   0.36718   1.73174nH   0.18738pF
   14   GND   GND   0.40372   1.92738nH   0.17766pF
   15   VCC   POWER   0.20323   1.55915nH   0.22711pF
   16   OUTP1   PECL_OUT   0.37026   1.74564nH   0.19232pF
   17   OUTN1   PECL_OUT   0.34486   1.61030nH   0.17896pF
   18   OUTP2   PECL_OUT   0.33606   1.56273nH   0.17520pF
   19   OUTN2   PECL_OUT   0.34529   1.60990nH   0.17885pF
   20   OUTP3   PECL_OUT   0.37105   1.74484nH   0.18893pF
   21   OUTN3   PECL_OUT   0.40991   1.95238nH   0.17780pF
   22   OUTP4   PECL_OUT   0.41637   1.98558nH   0.17997pF
   23   OUTN4   PECL_OUT   0.37690   1.77334nH   0.19100pF
   24   OUTP5   PECL_OUT   0.35016   1.63170nH   0.18046pF
   25   OUTN5   PECL_OUT   0.33957   1.57583nH   0.17618pF
   26   OUTP6   PECL_OUT   0.34680   1.61400nH   0.17927pF
   27   OUTN6   PECL_OUT   0.37068   1.74054nH   0.19195pF
   28   VCC   POWER   0.20285   1.53973nH   0.22849pF
[Diff_Pin]  inv_pin  vdiff   tdelay_typ  tdelay_min  tdelay_max
| The '+' pin is   Diff_pin,   the '-' pin is the   Inv_pin
| Receiver Pins  |  Receiver Vth = +/-200mV
5   6   0.8V   0ns   0ns   0ns
9   10   0.8V   0ns   0ns   0ns
| LVPECL Driver Pins
2   3   0.5V   0ns   0ns   0ns
12   13   0.5V   0ns   0ns   0ns
16   17   0.5V   0ns   0ns   0ns
18   19   0.5V   0ns   0ns   0ns
20   21   0.5V   0ns   0ns   0ns
22   23   0.5V   0ns   0ns   0ns
24   25   0.5V   0ns   0ns   0ns
26   27   0.5V   0ns   0ns   0ns
| Pulldown resistor on SEL_IN, series model of 150kOhm to GND
[Model]   PDN_SEL_IN
Model_type   Series
C_comp   0pF   0pF   0pF
[Voltage Range]   3.3V   2.375V   3.6V
[Pullup Reference]   3.3V   2.375V   3.6V
| Junction Temperature (Ambient temp is 25C typ, 85C min, -40C max)
[Temperature Range]   40.0   100.0   -40.0
[R series]   150000   150000   150000
| Models and submodels in the file (5): PDN_SEL_IN (Series), VAC_REF (Terminator), INPUT (Input), SEL_IN (Input), PECL_OUT (Output_ECL)

[IBIS Ver]   3.2
[Comment Char] |_char
[File Name]   FMC_ADC.ibs
[File Rev]   3.0
[Source]
| This model file was created by Teraspeed Consulting Group LLC
| (http://www.teraspeed.com/).
[Date]   09-03-2008
[Notes]   Quality Check of this IBIS model: Model Passes IBIS Check
   Model parses into ICX IS. Simulation done with Hyperlynx.
   1. MIN TYP MAX information is based on Temperature and Voltage
   characteristics only.
[Disclaimer]
| This model is designed as an aid for customers of Texas Instruments.
| TI and its licensors and suppliers make no warranties, either expressed
| or implied, with respect to this  model, including the warranties of
| merchantability or fitness for a particular purpose.
| The model is provided solely on an "as is" basis. The entire risk as to
| its quality and performance is with the customer.
[Copyright]
|  (C) Copyright 2008 Texas Instruments Incorporated. All rights reserved.
[Component]   ADS5463
[Manufacturer] TI
[Package]
| variable   typ   min   max
R_pkg  1.550E-01   1.256E-01   2.000E-01
L_pkg  2.837E-09   2.298E-09   3.660E-09
C_pkg  6.953E-13   5.633E-13   8.970E-13
[Pin] signal_name  model_name  R_pin  L_pin C_pin
G6  LA00_P   lvds_out  1.324E-01 2.423E-09 5.939E-13
G7  LA00_N   lvds_out  1.382E-01 2.530E-09 6.200E-13
D8  LA01_P   lvds_out  1.324E-01 2.423E-09 5.939E-13
D9  LA01_N   lvds_out  1.382E-01 2.530E-09 6.200E-13
H7  LA02_P   lvds_out  1.324E-01 2.423E-09 5.939E-13
H8  LA02_N   lvds_out  1.382E-01 2.530E-09 6.200E-13
G9  LA03_P   lvds_out  1.324E-01 2.423E-09 5.939E-13
G10 LA03_N   lvds_out  1.382E-01 2.530E-09 6.200E-13
H10 LA04_P   lvds_out  1.324E-01 2.423E-09 5.939E-13
H11 LA04_N   lvds_out  1.382E-01 2.530E-09 6.200E-13
D11 LA05_P   lvds_out  1.324E-01 2.423E-09 5.939E-13
D12 LA05_N   lvds_out  1.382E-01 2.530E-09 6.200E-13
C10 LA06_P   lvds_out  1.324E-01 2.423E-09 5.939E-13
C11 LA06_N   lvds_out  1.382E-01 2.530E-09 6.200E-13
H13 LA07_P   lvds_out  1.324E-01 2.423E-09 5.939E-13
H14 LA07_N   lvds_out  1.382E-01 2.530E-09 6.200E-13
G12 LA08_P   lvds_out  1.324E-01 2.423E-09 5.939E-13
G13 LA08_N   lvds_out  1.382E-01 2.530E-09 6.200E-13
D14 LA09_P   lvds_out  1.324E-01 2.423E-09 5.939E-13
D15 LA09_N   lvds_out  1.382E-01 2.530E-09 6.200E-13
C14 LA10_P   lvds_out  1.324E-01 2.423E-09 5.939E-13
C15 LA10_N   lvds_out  1.382E-01 2.530E-09 6.200E-13
H16 LA11_P   lvds_out  1.324E-01 2.423E-09 5.939E-13
H17 LA11_N   lvds_out  1.382E-01 2.530E-09 6.200E-13
G15 LA12_P   lvds_out  1.324E-01 2.423E-09 5.939E-13
G16 LA12_N   lvds_out  1.382E-01 2.530E-09 6.200E-13
D17 LA13_P   lvds_out  1.324E-01 2.423E-09 5.939E-13
D18 LA13_N   lvds_out  1.382E-01 2.530E-09 6.200E-13
C18 LA14_P   lvds_out  1.324E-01 2.423E-09 5.939E-13
C19 LA14_N   lvds_out  1.382E-01 2.530E-09 6.200E-13
H19 LA15_P   lvds_out  1.324E-01 2.423E-09 5.939E-13
H20 LA15_N   lvds_out  1.382E-01 2.530E-09 6.200E-13
G18 LA16_P   lvds_out  1.324E-01 2.423E-09 5.939E-13
G19 LA16_N   lvds_out  1.382E-01 2.530E-09 6.200E-13
D20 LA17_P   lvds_out  1.324E-01 2.423E-09 5.939E-13
D21 LA17_N   lvds_out  1.382E-01 2.530E-09 6.200E-13
C22 LA18_P   lvds_out  1.324E-01 2.423E-09 5.939E-13
C23 LA18_N   lvds_out  1.382E-01 2.530E-09 6.200E-13
H22 LA19_P   lvds_out  1.324E-01 2.423E-09 5.939E-13
H23 LA19_N   lvds_out  1.382E-01 2.530E-09 6.200E-13
G21 LA20_P   lvds_out  1.324E-01 2.423E-09 5.939E-13
G22 LA20_N   lvds_out  1.382E-01 2.530E-09 6.200E-13
H25 LA21_P   lvds_out  1.324E-01 2.423E-09 5.939E-13
H26 LA21_N   lvds_out  1.382E-01 2.530E-09 6.200E-13
G24 LA22_P   lvds_out  1.324E-01 2.423E-09 5.939E-13
G25 LA22_N   lvds_out  1.382E-01 2.530E-09 6.200E-13
D23 LA23_P   lvds_out  1.324E-01 2.423E-09 5.939E-13
D24 LA23_N   lvds_out  1.382E-01 2.530E-09 6.200E-13
H28 LA24_P   lvds_out  1.324E-01 2.423E-09 5.939E-13
H29 LA24_N   lvds_out  1.382E-01 2.530E-09 6.200E-13
G27 LA25_P   lvds_out  1.324E-01 2.423E-09 5.939E-13
G28 LA25_N   lvds_out  1.382E-01 2.530E-09 6.200E-13
D26 LA26_P   lvds_out  1.324E-01 2.423E-09 5.939E-13
D27 LA26_N   lvds_out  1.382E-01 2.530E-09 6.200E-13
C26 LA27_P   lvds_out  1.324E-01 2.423E-09 5.939E-13
C27 LA27_N   lvds_out  1.382E-01 2.530E-09 6.200E-13
H31 LA28_P   lvds_out  1.324E-01 2.423E-09 5.939E-13
H32 LA28_N   lvds_out  1.382E-01 2.530E-09 6.200E-13
G30 LA29_P   lvds_out  1.324E-01 2.423E-09 5.939E-13
G31 LA29_N   lvds_out  1.382E-01 2.530E-09 6.200E-13
H34 LA30_P   lvds_out  1.324E-01 2.423E-09 5.939E-13
H35 LA30_N   lvds_out  1.382E-01 2.530E-09 6.200E-13
G33 LA31_P   lvds_out  1.324E-01 2.423E-09 5.939E-13
G34 LA31_N   lvds_out  1.382E-01 2.530E-09 6.200E-13
H37 LA32_P   lvds_out  1.324E-01 2.423E-09 5.939E-13
H38 LA32_N   lvds_out  1.382E-01 2.530E-09 6.200E-13
G36 LA33_P   lvds_out  1.324E-01 2.423E-09 5.939E-13
G37 LA33_N   lvds_out  1.382E-01 2.530E-09 6.200E-13
E2  HA01_P   lvds_out  1.324E-01 2.423E-09 5.939E-13
E3  HA01_N   lvds_out  1.382E-01 2.530E-09 6.200E-13
E6  HA05_P   lvds_out  1.324E-01 2.423E-09 5.939E-13
E7  HA05_N   lvds_out  1.382E-01 2.530E-09 6.200E-13
E9  HA09_P   lvds_out  1.324E-01 2.423E-09 5.939E-13
E10 HA09_N   lvds_out  1.382E-01 2.530E-09 6.200E-13
E12 HA13_P   lvds_out  1.324E-01 2.423E-09 5.939E-13
E13 HA13_N   lvds_out  1.382E-01 2.530E-09 6.200E-13
H4  CLK0_M2C_P   lvds_out  1.324E-01 2.423E-09 5.939E-13
H5  CLK0_M2C_N   lvds_out  1.382E-01 2.530E-09 6.200E-13
G2  CLK1_M2C_P   lvds_out  1.324E-01 2.423E-09 5.939E-13
G3  CLK1_M2C_P   lvds_out  1.382E-01 2.530E-09 6.200E-13
[Diff Pin] inv_pin vdiff tdelay_typ tdelay_min tdelay_max
G6   G7   NA   NA   NA   NA
D8   D9   NA   NA   NA   NA
H7   H8   NA   NA   NA   NA
G9   G10   NA   NA   NA   NA
H10  H11   NA   NA   NA   NA
D11  D12   NA   NA   NA   NA
C10  C11   NA   NA   NA   NA
H13  H14   NA   NA   NA   NA
G12  G13   NA   NA   NA   NA
D14  D15   NA   NA   NA   NA
C14  C15   NA   NA   NA   NA
H16  H17   NA   NA   NA   NA
G15  G16   NA   NA   NA   NA
D17  D18   NA   NA   NA   NA
C18  C19   NA   NA   NA   NA
H19  H20   NA   NA   NA   NA
G18  G19   NA   NA   NA   NA
D20  D21   NA   NA   NA   NA
C22  C23   NA   NA   NA   NA
H22  H23   NA   NA   NA   NA
G21  G22   NA   NA   NA   NA
H25  H26   NA   NA   NA   NA
G24  G25   NA   NA   NA   NA
D23  D24   NA   NA   NA   NA
H28  H29   NA   NA   NA   NA
G27  G28   NA   NA   NA   NA
D26  D27   NA   NA   NA   NA
C26  C27   NA   NA   NA   NA
H31  H32   NA   NA   NA   NA
G30  G31   NA   NA   NA   NA
H34  H35   NA   NA   NA   NA
G33  G34   NA   NA   NA   NA
H37  H38   NA   NA   NA   NA
G36  G37   NA   NA   NA   NA
E2   E3   NA   NA   NA   NA
E6   E7   NA   NA   NA   NA
E9   E10   NA   NA   NA   NA
E12  E13   NA   NA   NA   NA
H4   H5   NA   NA   NA   NA
G2   G3   NA   NA   NA   NA
|[Model]   lvds_out
|Model_type Output
|Vref=1.250E+00
|Rref=5.000E+01
|Cref=0.0E+00
|Vmeas=1.250E+00
|C_comp   5.750E-13   5.750E-13   5.750E-13
|[Voltage Range]   3.300E+00   3.000E+00   3.600E+00
|[POWER Clamp Reference]   3.300E+00   3.000E+00   3.600E+00
|[GND Clamp Reference]   0.000E+00   0.000E+00   0.000E+00
|[Pullup Reference]   3.300E+00   3.000E+00   3.600E+00
|[Pulldown Reference]   0.000E+00   0.000E+00   0.000E+00
|[Temperature Range]   25   85   -40
|[GND Clamp]
|-3.60000V   -572.930mA   -589.171mA   -487.460mA
|-3.30000V   -511.353mA   -526.409mA   -434.848mA
|-3.00000V   -449.777mA   -463.646mA   -382.236mA
|-920.000mV   -22.8497mA   -28.4912mA   -17.4611mA
|-900.000mV   -19.9808mA   -24.3070mA   -13.9536mA
|-880.000mV   -17.1119mA   -21.3742mA   -10.4461mA
|-820.000mV   -8.50527mA   -12.5756mA   -4.28502mA
|-800.000mV   -7.01330mA   -9.64279mA   -3.18512mA
|-780.000mV   -5.52134mA   -8.00185mA   -2.08522mA
|-740.000mV   -2.53741mA   -4.71999mA   -1.08921mA
|-720.000mV   -1.97449mA   -3.07905mA   -937.856uA
|-700.000mV   -1.41157mA   -2.46248mA   -786.503uA
|-680.000mV   -1.17109mA   -1.84590mA   -635.150uA
|-660.000mV   -930.622uA   -1.22933mA   -597.788uA
|-600.000mV   -773.576uA   -744.839uA   -485.703uA
|-480.000mV   -459.484uA   -446.904uA   -261.532uA
|-340.000mV   -191.452uA   -99.3119uA   0.00000A
|-300.000mV   -114.871uA   0.00000A   0.00000A
|-240.000mV   0.00000A   0.00000A   0.00000A
|0.00000V   0.00000A   0.00000A   0.00000A
|6.00000V   0.00000A   0.00000A   0.00000A
|6.60000V   0.00000A   0.00000A   0.00000A
|7.20000V   0.00000A   0.00000A   0.00000A
|[POWER Clamp]
|6.90000V   0.00000A   0.00000A   0.00000A
|6.60000V   0.00000A   0.00000A   0.00000A
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[Model] term
Model_type Terminator
C_comp   0  0  0
| variable   typ   min   max
[Voltage Range]   5.00000V  4.75000V  5.25000V
[POWER Clamp Reference]  5.00000V  4.75000V  5.25000V
[GND Clamp Reference]   0.00000V  0.00000V  0.00000V
[Temperature Range]   25   85   -40
| Models and submodels in the file (2): lvds_out (Output), term (Terminator)
